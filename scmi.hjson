// Copyright lowRISC contributors.
// Licensed under the Apache License, Version 2.0, see LICENSE for details.
// SPDX-License-Identifier: Apache-2.0
# SCMI register template
# - src: Number of mailbox channels. Following is the memory layout of one channel.
{
  name: "scmi",
  clock_primary: "clk_i",
  bus_interfaces: [
        { protocol: "reg_iface", direction: "device"}
    ],
  regwidth: "32",
  registers: [
    { name: "Reserved_1_c0",
      desc: "Reserved, must be 0",
      swaccess: "rw",
      hwaccess: "none",
      fields: [
        { bits: "31:0" }
      ],
    },
    { name: "Channel_Status_c0",
      desc: "Indicates which entity has access to the Shared Memory",
      swaccess: "rw",
      hwaccess: "none",
      fields: [
        { bits: "31:2" },
        { bits: "1",
          name: "channel_error",
          desc: "Must be 0 in absence of errors"
        },
        { bits: "0",
          name: "channel_free",
          desc: "If 1 the agent own the channel, if 0 the platform own the channel"
        }
      ],
    },
    { name: "Reserved_2_c0",
      desc: "Reserved, implementation defined (32 bits over 64)",
      swaccess: "rw",
      hwaccess: "none",
      fields: [
        { bits: "31:0" }
      ],
    },
    { name: "Reserved_3_c0",
      desc: "Reserved, implementation defined (32 bits over 64)",
      swaccess: "none",
      hwaccess: "none",
      fields: [
        { bits: "31:0" }
      ],
    },
    { name: "Channel_Flags_c0",
      desc: "Defines wheter interrupts or polling is used for communication",
      swaccess: "rw",
      hwaccess: "none",
      fields: [
        { bits: "31:1" },
        { bits: "0",
          name: "intr_enable",
          desc: "If 1 interruts are used, if 0 polling is used"
        }
      ],
    },
    { name: "Length_c0",
      desc: "Lenght of payload + header",
      swaccess: "rw",
      hwaccess: "none",
      fields: [
        { bits: "31:0" }
      ],
    },
    { name: "Message_Header_c0",
      desc: "Defines which commanad the message contains",
      swaccess: "rw",
      hwaccess: "none",
      fields: [
        { bits: "31:28" },
        { bits: "27:18",
          name: "Token",
          desc: "must be same for the msg responses associated to a msg whith the same header"
        },
        { bits: "17:10",
          name: "Protocol_Id",
          desc: "Identifies to which protocol the command belongs to"
        },
        { bits: "9:8",
          name: "Message_Type",
          desc: "can be 0,1,2,3 depending on the kind of msg to be sent"
        },
        { bits: "7:0",
          name: "Message_Id",
          desc: "unique identifier for each command availabe in the protocol pointed by protocol_id"
        }
      ],
    },
    { name: "Message_Payload_1_c0",
      desc: "memory region dedicated to the parameters of the commands and their returns",
      swaccess: "rw",
      hwaccess: "none",
      fields: [
        { bits: "31:0" }
      ],
    },
    { name: "Doorbell_c0",
      desc: "Rapresents the interrupt to be raised towards the platform",
      swaccess: "rw",
      hwaccess: "hro",
      fields: [
        { bits: "31:1",
          name: "Preserve_Mask",
          desc: "These bits must be constant to 0, not used with just one platform and one agent"
        },
        { bits: "0",
          name: "intr",
          desc: "Interrupt bit"
        }
      ],
    },
    { name:  "Completion_Interrupt_c0",
      desc: "Rapresent the interrupt the platform should raise when it finishes to execute the received command",
      swaccess: "rw",
      hwaccess: "hro",
      fields: [
        { bits: "31:1",
          name: "Preserve_Mask",
          desc: "These bits must be constant to 0, not used with just one platform and one agent"
        },
        { bits: "0",
          name: "intr",
          desc: "Interrupt bit"
        }
      ],
    },
    { name: "Reserved_1_c1",
      desc: "Reserved, must be 0",
      swaccess: "rw",
      hwaccess: "none",
      fields: [
        { bits: "31:0" }
      ],
    },
    { name: "Channel_Status_c1",
      desc: "Indicates which entity has access to the Shared Memory",
      swaccess: "rw",
      hwaccess: "none",
      fields: [
        { bits: "31:2" },
        { bits: "1",
          name: "channel_error",
          desc: "Must be 0 in absence of errors"
        },
        { bits: "0",
          name: "channel_free",
          desc: "If 1 the agent own the channel, if 0 the platform own the channel"
        }
      ],
    },
    { name: "Reserved_2_c1",
      desc: "Reserved, implementation defined (32 bits over 64)",
      swaccess: "rw",
      hwaccess: "none",
      fields: [
        { bits: "31:0" }
      ],
    },
    { name: "Reserved_3_c1",
      desc: "Reserved, implementation defined (32 bits over 64)",
      swaccess: "none",
      hwaccess: "none",
      fields: [
        { bits: "31:0" }
      ],
    },
    { name: "Channel_Flags_c1",
      desc: "Defines wheter interrupts or polling is used for communication",
      swaccess: "rw",
      hwaccess: "none",
      fields: [
        { bits: "31:1" },
        { bits: "0",
          name: "intr_enable",
          desc: "If 1 interruts are used, if 0 polling is used"
        }
      ],
    },
    { name: "Length_c1",
      desc: "Lenght of payload + header",
      swaccess: "rw",
      hwaccess: "none",
      fields: [
        { bits: "31:0" }
      ],
    },
    { name: "Message_Header_c1",
      desc: "Defines which commanad the message contains",
      swaccess: "rw",
      hwaccess: "none",
      fields: [
        { bits: "31:28" },
        { bits: "27:18",
          name: "Token",
          desc: "must be same for the msg responses associated to a msg whith the same header"
        },
        { bits: "17:10",
          name: "Protocol_Id",
          desc: "Identifies to which protocol the command belongs to"
        },
        { bits: "9:8",
          name: "Message_Type",
          desc: "can be 0,1,2,3 depending on the kind of msg to be sent"
        },
        { bits: "7:0",
          name: "Message_Id",
          desc: "unique identifier for each command availabe in the protocol pointed by protocol_id"
        }
      ],
    },
    { name: "Message_Payload_1_c1",
      desc: "memory region dedicated to the parameters of the commands and their returns",
      swaccess: "rw",
      hwaccess: "none",
      fields: [
        { bits: "31:0" }
      ],
    },
    { name: "Doorbell_c1",
      desc: "Rapresents the interrupt to be raised towards the platform",
      swaccess: "rw",
      hwaccess: "hro",
      fields: [
        { bits: "31:1",
          name: "Preserve_Mask",
          desc: "These bits must be constant to 0, not used with just one platform and one agent"
        },
        { bits: "0",
          name: "intr",
          desc: "Interrupt bit"
        }
      ],
    },
    { name:  "Completion_Interrupt_c1",
      desc: "Rapresent the interrupt the platform should raise when it finishes to execute the received command",
      swaccess: "rw",
      hwaccess: "hro",
      fields: [
        { bits: "31:1",
          name: "Preserve_Mask",
          desc: "These bits must be constant to 0, not used with just one platform and one agent"
        },
        { bits: "0",
          name: "intr",
          desc: "Interrupt bit"
        }
      ],
    },
    { name: "Reserved_1_c2",
      desc: "Reserved, must be 0",
      swaccess: "rw",
      hwaccess: "none",
      fields: [
        { bits: "31:0" }
      ],
    },
    { name: "Channel_Status_c2",
      desc: "Indicates which entity has access to the Shared Memory",
      swaccess: "rw",
      hwaccess: "none",
      fields: [
        { bits: "31:2" },
        { bits: "1",
          name: "channel_error",
          desc: "Must be 0 in absence of errors"
        },
        { bits: "0",
          name: "channel_free",
          desc: "If 1 the agent own the channel, if 0 the platform own the channel"
        }
      ],
    },
    { name: "Reserved_2_c2",
      desc: "Reserved, implementation defined (32 bits over 64)",
      swaccess: "rw",
      hwaccess: "none",
      fields: [
        { bits: "31:0" }
      ],
    },
    { name: "Reserved_3_c2",
      desc: "Reserved, implementation defined (32 bits over 64)",
      swaccess: "none",
      hwaccess: "none",
      fields: [
        { bits: "31:0" }
      ],
    },
    { name: "Channel_Flags_c2",
      desc: "Defines wheter interrupts or polling is used for communication",
      swaccess: "rw",
      hwaccess: "none",
      fields: [
        { bits: "31:1" },
        { bits: "0",
          name: "intr_enable",
          desc: "If 1 interruts are used, if 0 polling is used"
        }
      ],
    },
    { name: "Length_c2",
      desc: "Lenght of payload + header",
      swaccess: "rw",
      hwaccess: "none",
      fields: [
        { bits: "31:0" }
      ],
    },
    { name: "Message_Header_c2",
      desc: "Defines which commanad the message contains",
      swaccess: "rw",
      hwaccess: "none",
      fields: [
        { bits: "31:28" },
        { bits: "27:18",
          name: "Token",
          desc: "must be same for the msg responses associated to a msg whith the same header"
        },
        { bits: "17:10",
          name: "Protocol_Id",
          desc: "Identifies to which protocol the command belongs to"
        },
        { bits: "9:8",
          name: "Message_Type",
          desc: "can be 0,1,2,3 depending on the kind of msg to be sent"
        },
        { bits: "7:0",
          name: "Message_Id",
          desc: "unique identifier for each command availabe in the protocol pointed by protocol_id"
        }
      ],
    },
    { name: "Message_Payload_1_c2",
      desc: "memory region dedicated to the parameters of the commands and their returns",
      swaccess: "rw",
      hwaccess: "none",
      fields: [
        { bits: "31:0" }
      ],
    },
    { name: "Doorbell_c2",
      desc: "Rapresents the interrupt to be raised towards the platform",
      swaccess: "rw",
      hwaccess: "hro",
      fields: [
        { bits: "31:1",
          name: "Preserve_Mask",
          desc: "These bits must be constant to 0, not used with just one platform and one agent"
        },
        { bits: "0",
          name: "intr",
          desc: "Interrupt bit"
        }
      ],
    },
    { name:  "Completion_Interrupt_c2",
      desc: "Rapresent the interrupt the platform should raise when it finishes to execute the received command",
      swaccess: "rw",
      hwaccess: "hro",
      fields: [
        { bits: "31:1",
          name: "Preserve_Mask",
          desc: "These bits must be constant to 0, not used with just one platform and one agent"
        },
        { bits: "0",
          name: "intr",
          desc: "Interrupt bit"
        }
      ],
    },
    { name: "Reserved_1_c3",
      desc: "Reserved, must be 0",
      swaccess: "rw",
      hwaccess: "none",
      fields: [
        { bits: "31:0" }
      ],
    },
    { name: "Channel_Status_c3",
      desc: "Indicates which entity has access to the Shared Memory",
      swaccess: "rw",
      hwaccess: "none",
      fields: [
        { bits: "31:2" },
        { bits: "1",
          name: "channel_error",
          desc: "Must be 0 in absence of errors"
        },
        { bits: "0",
          name: "channel_free",
          desc: "If 1 the agent own the channel, if 0 the platform own the channel"
        }
      ],
    },
    { name: "Reserved_2_c3",
      desc: "Reserved, implementation defined (32 bits over 64)",
      swaccess: "rw",
      hwaccess: "none",
      fields: [
        { bits: "31:0" }
      ],
    },
    { name: "Reserved_3_c3",
      desc: "Reserved, implementation defined (32 bits over 64)",
      swaccess: "none",
      hwaccess: "none",
      fields: [
        { bits: "31:0" }
      ],
    },
    { name: "Channel_Flags_c3",
      desc: "Defines wheter interrupts or polling is used for communication",
      swaccess: "rw",
      hwaccess: "none",
      fields: [
        { bits: "31:1" },
        { bits: "0",
          name: "intr_enable",
          desc: "If 1 interruts are used, if 0 polling is used"
        }
      ],
    },
    { name: "Length_c3",
      desc: "Lenght of payload + header",
      swaccess: "rw",
      hwaccess: "none",
      fields: [
        { bits: "31:0" }
      ],
    },
    { name: "Message_Header_c3",
      desc: "Defines which commanad the message contains",
      swaccess: "rw",
      hwaccess: "none",
      fields: [
        { bits: "31:28" },
        { bits: "27:18",
          name: "Token",
          desc: "must be same for the msg responses associated to a msg whith the same header"
        },
        { bits: "17:10",
          name: "Protocol_Id",
          desc: "Identifies to which protocol the command belongs to"
        },
        { bits: "9:8",
          name: "Message_Type",
          desc: "can be 0,1,2,3 depending on the kind of msg to be sent"
        },
        { bits: "7:0",
          name: "Message_Id",
          desc: "unique identifier for each command availabe in the protocol pointed by protocol_id"
        }
      ],
    },
    { name: "Message_Payload_1_c3",
      desc: "memory region dedicated to the parameters of the commands and their returns",
      swaccess: "rw",
      hwaccess: "none",
      fields: [
        { bits: "31:0" }
      ],
    },
    { name: "Doorbell_c3",
      desc: "Rapresents the interrupt to be raised towards the platform",
      swaccess: "rw",
      hwaccess: "hro",
      fields: [
        { bits: "31:1",
          name: "Preserve_Mask",
          desc: "These bits must be constant to 0, not used with just one platform and one agent"
        },
        { bits: "0",
          name: "intr",
          desc: "Interrupt bit"
        }
      ],
    },
    { name:  "Completion_Interrupt_c3",
      desc: "Rapresent the interrupt the platform should raise when it finishes to execute the received command",
      swaccess: "rw",
      hwaccess: "hro",
      fields: [
        { bits: "31:1",
          name: "Preserve_Mask",
          desc: "These bits must be constant to 0, not used with just one platform and one agent"
        },
        { bits: "0",
          name: "intr",
          desc: "Interrupt bit"
        }
      ],
    },
    { name: "Reserved_1_c4",
      desc: "Reserved, must be 0",
      swaccess: "rw",
      hwaccess: "none",
      fields: [
        { bits: "31:0" }
      ],
    },
    { name: "Channel_Status_c4",
      desc: "Indicates which entity has access to the Shared Memory",
      swaccess: "rw",
      hwaccess: "none",
      fields: [
        { bits: "31:2" },
        { bits: "1",
          name: "channel_error",
          desc: "Must be 0 in absence of errors"
        },
        { bits: "0",
          name: "channel_free",
          desc: "If 1 the agent own the channel, if 0 the platform own the channel"
        }
      ],
    },
    { name: "Reserved_2_c4",
      desc: "Reserved, implementation defined (32 bits over 64)",
      swaccess: "rw",
      hwaccess: "none",
      fields: [
        { bits: "31:0" }
      ],
    },
    { name: "Reserved_3_c4",
      desc: "Reserved, implementation defined (32 bits over 64)",
      swaccess: "none",
      hwaccess: "none",
      fields: [
        { bits: "31:0" }
      ],
    },
    { name: "Channel_Flags_c4",
      desc: "Defines wheter interrupts or polling is used for communication",
      swaccess: "rw",
      hwaccess: "none",
      fields: [
        { bits: "31:1" },
        { bits: "0",
          name: "intr_enable",
          desc: "If 1 interruts are used, if 0 polling is used"
        }
      ],
    },
    { name: "Length_c4",
      desc: "Lenght of payload + header",
      swaccess: "rw",
      hwaccess: "none",
      fields: [
        { bits: "31:0" }
      ],
    },
    { name: "Message_Header_c4",
      desc: "Defines which commanad the message contains",
      swaccess: "rw",
      hwaccess: "none",
      fields: [
        { bits: "31:28" },
        { bits: "27:18",
          name: "Token",
          desc: "must be same for the msg responses associated to a msg whith the same header"
        },
        { bits: "17:10",
          name: "Protocol_Id",
          desc: "Identifies to which protocol the command belongs to"
        },
        { bits: "9:8",
          name: "Message_Type",
          desc: "can be 0,1,2,3 depending on the kind of msg to be sent"
        },
        { bits: "7:0",
          name: "Message_Id",
          desc: "unique identifier for each command availabe in the protocol pointed by protocol_id"
        }
      ],
    },
    { name: "Message_Payload_1_c4",
      desc: "memory region dedicated to the parameters of the commands and their returns",
      swaccess: "rw",
      hwaccess: "none",
      fields: [
        { bits: "31:0" }
      ],
    },
    { name: "Doorbell_c4",
      desc: "Rapresents the interrupt to be raised towards the platform",
      swaccess: "rw",
      hwaccess: "hro",
      fields: [
        { bits: "31:1",
          name: "Preserve_Mask",
          desc: "These bits must be constant to 0, not used with just one platform and one agent"
        },
        { bits: "0",
          name: "intr",
          desc: "Interrupt bit"
        }
      ],
    },
    { name:  "Completion_Interrupt_c4",
      desc: "Rapresent the interrupt the platform should raise when it finishes to execute the received command",
      swaccess: "rw",
      hwaccess: "hro",
      fields: [
        { bits: "31:1",
          name: "Preserve_Mask",
          desc: "These bits must be constant to 0, not used with just one platform and one agent"
        },
        { bits: "0",
          name: "intr",
          desc: "Interrupt bit"
        }
      ],
    },
    { name: "Reserved_1_c5",
      desc: "Reserved, must be 0",
      swaccess: "rw",
      hwaccess: "none",
      fields: [
        { bits: "31:0" }
      ],
    },
    { name: "Channel_Status_c5",
      desc: "Indicates which entity has access to the Shared Memory",
      swaccess: "rw",
      hwaccess: "none",
      fields: [
        { bits: "31:2" },
        { bits: "1",
          name: "channel_error",
          desc: "Must be 0 in absence of errors"
        },
        { bits: "0",
          name: "channel_free",
          desc: "If 1 the agent own the channel, if 0 the platform own the channel"
        }
      ],
    },
    { name: "Reserved_2_c5",
      desc: "Reserved, implementation defined (32 bits over 64)",
      swaccess: "rw",
      hwaccess: "none",
      fields: [
        { bits: "31:0" }
      ],
    },
    { name: "Reserved_3_c5",
      desc: "Reserved, implementation defined (32 bits over 64)",
      swaccess: "none",
      hwaccess: "none",
      fields: [
        { bits: "31:0" }
      ],
    },
    { name: "Channel_Flags_c5",
      desc: "Defines wheter interrupts or polling is used for communication",
      swaccess: "rw",
      hwaccess: "none",
      fields: [
        { bits: "31:1" },
        { bits: "0",
          name: "intr_enable",
          desc: "If 1 interruts are used, if 0 polling is used"
        }
      ],
    },
    { name: "Length_c5",
      desc: "Lenght of payload + header",
      swaccess: "rw",
      hwaccess: "none",
      fields: [
        { bits: "31:0" }
      ],
    },
    { name: "Message_Header_c5",
      desc: "Defines which commanad the message contains",
      swaccess: "rw",
      hwaccess: "none",
      fields: [
        { bits: "31:28" },
        { bits: "27:18",
          name: "Token",
          desc: "must be same for the msg responses associated to a msg whith the same header"
        },
        { bits: "17:10",
          name: "Protocol_Id",
          desc: "Identifies to which protocol the command belongs to"
        },
        { bits: "9:8",
          name: "Message_Type",
          desc: "can be 0,1,2,3 depending on the kind of msg to be sent"
        },
        { bits: "7:0",
          name: "Message_Id",
          desc: "unique identifier for each command availabe in the protocol pointed by protocol_id"
        }
      ],
    },
    { name: "Message_Payload_1_c5",
      desc: "memory region dedicated to the parameters of the commands and their returns",
      swaccess: "rw",
      hwaccess: "none",
      fields: [
        { bits: "31:0" }
      ],
    },
    { name: "Doorbell_c5",
      desc: "Rapresents the interrupt to be raised towards the platform",
      swaccess: "rw",
      hwaccess: "hro",
      fields: [
        { bits: "31:1",
          name: "Preserve_Mask",
          desc: "These bits must be constant to 0, not used with just one platform and one agent"
        },
        { bits: "0",
          name: "intr",
          desc: "Interrupt bit"
        }
      ],
    },
    { name:  "Completion_Interrupt_c5",
      desc: "Rapresent the interrupt the platform should raise when it finishes to execute the received command",
      swaccess: "rw",
      hwaccess: "hro",
      fields: [
        { bits: "31:1",
          name: "Preserve_Mask",
          desc: "These bits must be constant to 0, not used with just one platform and one agent"
        },
        { bits: "0",
          name: "intr",
          desc: "Interrupt bit"
        }
      ],
    },
    { name: "Reserved_1_c6",
      desc: "Reserved, must be 0",
      swaccess: "rw",
      hwaccess: "none",
      fields: [
        { bits: "31:0" }
      ],
    },
    { name: "Channel_Status_c6",
      desc: "Indicates which entity has access to the Shared Memory",
      swaccess: "rw",
      hwaccess: "none",
      fields: [
        { bits: "31:2" },
        { bits: "1",
          name: "channel_error",
          desc: "Must be 0 in absence of errors"
        },
        { bits: "0",
          name: "channel_free",
          desc: "If 1 the agent own the channel, if 0 the platform own the channel"
        }
      ],
    },
    { name: "Reserved_2_c6",
      desc: "Reserved, implementation defined (32 bits over 64)",
      swaccess: "rw",
      hwaccess: "none",
      fields: [
        { bits: "31:0" }
      ],
    },
    { name: "Reserved_3_c6",
      desc: "Reserved, implementation defined (32 bits over 64)",
      swaccess: "none",
      hwaccess: "none",
      fields: [
        { bits: "31:0" }
      ],
    },
    { name: "Channel_Flags_c6",
      desc: "Defines wheter interrupts or polling is used for communication",
      swaccess: "rw",
      hwaccess: "none",
      fields: [
        { bits: "31:1" },
        { bits: "0",
          name: "intr_enable",
          desc: "If 1 interruts are used, if 0 polling is used"
        }
      ],
    },
    { name: "Length_c6",
      desc: "Lenght of payload + header",
      swaccess: "rw",
      hwaccess: "none",
      fields: [
        { bits: "31:0" }
      ],
    },
    { name: "Message_Header_c6",
      desc: "Defines which commanad the message contains",
      swaccess: "rw",
      hwaccess: "none",
      fields: [
        { bits: "31:28" },
        { bits: "27:18",
          name: "Token",
          desc: "must be same for the msg responses associated to a msg whith the same header"
        },
        { bits: "17:10",
          name: "Protocol_Id",
          desc: "Identifies to which protocol the command belongs to"
        },
        { bits: "9:8",
          name: "Message_Type",
          desc: "can be 0,1,2,3 depending on the kind of msg to be sent"
        },
        { bits: "7:0",
          name: "Message_Id",
          desc: "unique identifier for each command availabe in the protocol pointed by protocol_id"
        }
      ],
    },
    { name: "Message_Payload_1_c6",
      desc: "memory region dedicated to the parameters of the commands and their returns",
      swaccess: "rw",
      hwaccess: "none",
      fields: [
        { bits: "31:0" }
      ],
    },
    { name: "Doorbell_c6",
      desc: "Rapresents the interrupt to be raised towards the platform",
      swaccess: "rw",
      hwaccess: "hro",
      fields: [
        { bits: "31:1",
          name: "Preserve_Mask",
          desc: "These bits must be constant to 0, not used with just one platform and one agent"
        },
        { bits: "0",
          name: "intr",
          desc: "Interrupt bit"
        }
      ],
    },
    { name:  "Completion_Interrupt_c6",
      desc: "Rapresent the interrupt the platform should raise when it finishes to execute the received command",
      swaccess: "rw",
      hwaccess: "hro",
      fields: [
        { bits: "31:1",
          name: "Preserve_Mask",
          desc: "These bits must be constant to 0, not used with just one platform and one agent"
        },
        { bits: "0",
          name: "intr",
          desc: "Interrupt bit"
        }
      ],
    },
    { name: "Reserved_1_c7",
      desc: "Reserved, must be 0",
      swaccess: "rw",
      hwaccess: "none",
      fields: [
        { bits: "31:0" }
      ],
    },
    { name: "Channel_Status_c7",
      desc: "Indicates which entity has access to the Shared Memory",
      swaccess: "rw",
      hwaccess: "none",
      fields: [
        { bits: "31:2" },
        { bits: "1",
          name: "channel_error",
          desc: "Must be 0 in absence of errors"
        },
        { bits: "0",
          name: "channel_free",
          desc: "If 1 the agent own the channel, if 0 the platform own the channel"
        }
      ],
    },
    { name: "Reserved_2_c7",
      desc: "Reserved, implementation defined (32 bits over 64)",
      swaccess: "rw",
      hwaccess: "none",
      fields: [
        { bits: "31:0" }
      ],
    },
    { name: "Reserved_3_c7",
      desc: "Reserved, implementation defined (32 bits over 64)",
      swaccess: "none",
      hwaccess: "none",
      fields: [
        { bits: "31:0" }
      ],
    },
    { name: "Channel_Flags_c7",
      desc: "Defines wheter interrupts or polling is used for communication",
      swaccess: "rw",
      hwaccess: "none",
      fields: [
        { bits: "31:1" },
        { bits: "0",
          name: "intr_enable",
          desc: "If 1 interruts are used, if 0 polling is used"
        }
      ],
    },
    { name: "Length_c7",
      desc: "Lenght of payload + header",
      swaccess: "rw",
      hwaccess: "none",
      fields: [
        { bits: "31:0" }
      ],
    },
    { name: "Message_Header_c7",
      desc: "Defines which commanad the message contains",
      swaccess: "rw",
      hwaccess: "none",
      fields: [
        { bits: "31:28" },
        { bits: "27:18",
          name: "Token",
          desc: "must be same for the msg responses associated to a msg whith the same header"
        },
        { bits: "17:10",
          name: "Protocol_Id",
          desc: "Identifies to which protocol the command belongs to"
        },
        { bits: "9:8",
          name: "Message_Type",
          desc: "can be 0,1,2,3 depending on the kind of msg to be sent"
        },
        { bits: "7:0",
          name: "Message_Id",
          desc: "unique identifier for each command availabe in the protocol pointed by protocol_id"
        }
      ],
    },
    { name: "Message_Payload_1_c7",
      desc: "memory region dedicated to the parameters of the commands and their returns",
      swaccess: "rw",
      hwaccess: "none",
      fields: [
        { bits: "31:0" }
      ],
    },
    { name: "Doorbell_c7",
      desc: "Rapresents the interrupt to be raised towards the platform",
      swaccess: "rw",
      hwaccess: "hro",
      fields: [
        { bits: "31:1",
          name: "Preserve_Mask",
          desc: "These bits must be constant to 0, not used with just one platform and one agent"
        },
        { bits: "0",
          name: "intr",
          desc: "Interrupt bit"
        }
      ],
    },
    { name:  "Completion_Interrupt_c7",
      desc: "Rapresent the interrupt the platform should raise when it finishes to execute the received command",
      swaccess: "rw",
      hwaccess: "hro",
      fields: [
        { bits: "31:1",
          name: "Preserve_Mask",
          desc: "These bits must be constant to 0, not used with just one platform and one agent"
        },
        { bits: "0",
          name: "intr",
          desc: "Interrupt bit"
        }
      ],
    },
    { name: "Reserved_1_c8",
      desc: "Reserved, must be 0",
      swaccess: "rw",
      hwaccess: "none",
      fields: [
        { bits: "31:0" }
      ],
    },
    { name: "Channel_Status_c8",
      desc: "Indicates which entity has access to the Shared Memory",
      swaccess: "rw",
      hwaccess: "none",
      fields: [
        { bits: "31:2" },
        { bits: "1",
          name: "channel_error",
          desc: "Must be 0 in absence of errors"
        },
        { bits: "0",
          name: "channel_free",
          desc: "If 1 the agent own the channel, if 0 the platform own the channel"
        }
      ],
    },
    { name: "Reserved_2_c8",
      desc: "Reserved, implementation defined (32 bits over 64)",
      swaccess: "rw",
      hwaccess: "none",
      fields: [
        { bits: "31:0" }
      ],
    },
    { name: "Reserved_3_c8",
      desc: "Reserved, implementation defined (32 bits over 64)",
      swaccess: "none",
      hwaccess: "none",
      fields: [
        { bits: "31:0" }
      ],
    },
    { name: "Channel_Flags_c8",
      desc: "Defines wheter interrupts or polling is used for communication",
      swaccess: "rw",
      hwaccess: "none",
      fields: [
        { bits: "31:1" },
        { bits: "0",
          name: "intr_enable",
          desc: "If 1 interruts are used, if 0 polling is used"
        }
      ],
    },
    { name: "Length_c8",
      desc: "Lenght of payload + header",
      swaccess: "rw",
      hwaccess: "none",
      fields: [
        { bits: "31:0" }
      ],
    },
    { name: "Message_Header_c8",
      desc: "Defines which commanad the message contains",
      swaccess: "rw",
      hwaccess: "none",
      fields: [
        { bits: "31:28" },
        { bits: "27:18",
          name: "Token",
          desc: "must be same for the msg responses associated to a msg whith the same header"
        },
        { bits: "17:10",
          name: "Protocol_Id",
          desc: "Identifies to which protocol the command belongs to"
        },
        { bits: "9:8",
          name: "Message_Type",
          desc: "can be 0,1,2,3 depending on the kind of msg to be sent"
        },
        { bits: "7:0",
          name: "Message_Id",
          desc: "unique identifier for each command availabe in the protocol pointed by protocol_id"
        }
      ],
    },
    { name: "Message_Payload_1_c8",
      desc: "memory region dedicated to the parameters of the commands and their returns",
      swaccess: "rw",
      hwaccess: "none",
      fields: [
        { bits: "31:0" }
      ],
    },
    { name: "Doorbell_c8",
      desc: "Rapresents the interrupt to be raised towards the platform",
      swaccess: "rw",
      hwaccess: "hro",
      fields: [
        { bits: "31:1",
          name: "Preserve_Mask",
          desc: "These bits must be constant to 0, not used with just one platform and one agent"
        },
        { bits: "0",
          name: "intr",
          desc: "Interrupt bit"
        }
      ],
    },
    { name:  "Completion_Interrupt_c8",
      desc: "Rapresent the interrupt the platform should raise when it finishes to execute the received command",
      swaccess: "rw",
      hwaccess: "hro",
      fields: [
        { bits: "31:1",
          name: "Preserve_Mask",
          desc: "These bits must be constant to 0, not used with just one platform and one agent"
        },
        { bits: "0",
          name: "intr",
          desc: "Interrupt bit"
        }
      ],
    },
    { name: "Reserved_1_c9",
      desc: "Reserved, must be 0",
      swaccess: "rw",
      hwaccess: "none",
      fields: [
        { bits: "31:0" }
      ],
    },
    { name: "Channel_Status_c9",
      desc: "Indicates which entity has access to the Shared Memory",
      swaccess: "rw",
      hwaccess: "none",
      fields: [
        { bits: "31:2" },
        { bits: "1",
          name: "channel_error",
          desc: "Must be 0 in absence of errors"
        },
        { bits: "0",
          name: "channel_free",
          desc: "If 1 the agent own the channel, if 0 the platform own the channel"
        }
      ],
    },
    { name: "Reserved_2_c9",
      desc: "Reserved, implementation defined (32 bits over 64)",
      swaccess: "rw",
      hwaccess: "none",
      fields: [
        { bits: "31:0" }
      ],
    },
    { name: "Reserved_3_c9",
      desc: "Reserved, implementation defined (32 bits over 64)",
      swaccess: "none",
      hwaccess: "none",
      fields: [
        { bits: "31:0" }
      ],
    },
    { name: "Channel_Flags_c9",
      desc: "Defines wheter interrupts or polling is used for communication",
      swaccess: "rw",
      hwaccess: "none",
      fields: [
        { bits: "31:1" },
        { bits: "0",
          name: "intr_enable",
          desc: "If 1 interruts are used, if 0 polling is used"
        }
      ],
    },
    { name: "Length_c9",
      desc: "Lenght of payload + header",
      swaccess: "rw",
      hwaccess: "none",
      fields: [
        { bits: "31:0" }
      ],
    },
    { name: "Message_Header_c9",
      desc: "Defines which commanad the message contains",
      swaccess: "rw",
      hwaccess: "none",
      fields: [
        { bits: "31:28" },
        { bits: "27:18",
          name: "Token",
          desc: "must be same for the msg responses associated to a msg whith the same header"
        },
        { bits: "17:10",
          name: "Protocol_Id",
          desc: "Identifies to which protocol the command belongs to"
        },
        { bits: "9:8",
          name: "Message_Type",
          desc: "can be 0,1,2,3 depending on the kind of msg to be sent"
        },
        { bits: "7:0",
          name: "Message_Id",
          desc: "unique identifier for each command availabe in the protocol pointed by protocol_id"
        }
      ],
    },
    { name: "Message_Payload_1_c9",
      desc: "memory region dedicated to the parameters of the commands and their returns",
      swaccess: "rw",
      hwaccess: "none",
      fields: [
        { bits: "31:0" }
      ],
    },
    { name: "Doorbell_c9",
      desc: "Rapresents the interrupt to be raised towards the platform",
      swaccess: "rw",
      hwaccess: "hro",
      fields: [
        { bits: "31:1",
          name: "Preserve_Mask",
          desc: "These bits must be constant to 0, not used with just one platform and one agent"
        },
        { bits: "0",
          name: "intr",
          desc: "Interrupt bit"
        }
      ],
    },
    { name:  "Completion_Interrupt_c9",
      desc: "Rapresent the interrupt the platform should raise when it finishes to execute the received command",
      swaccess: "rw",
      hwaccess: "hro",
      fields: [
        { bits: "31:1",
          name: "Preserve_Mask",
          desc: "These bits must be constant to 0, not used with just one platform and one agent"
        },
        { bits: "0",
          name: "intr",
          desc: "Interrupt bit"
        }
      ],
    },
    { name: "Reserved_1_c10",
      desc: "Reserved, must be 0",
      swaccess: "rw",
      hwaccess: "none",
      fields: [
        { bits: "31:0" }
      ],
    },
    { name: "Channel_Status_c10",
      desc: "Indicates which entity has access to the Shared Memory",
      swaccess: "rw",
      hwaccess: "none",
      fields: [
        { bits: "31:2" },
        { bits: "1",
          name: "channel_error",
          desc: "Must be 0 in absence of errors"
        },
        { bits: "0",
          name: "channel_free",
          desc: "If 1 the agent own the channel, if 0 the platform own the channel"
        }
      ],
    },
    { name: "Reserved_2_c10",
      desc: "Reserved, implementation defined (32 bits over 64)",
      swaccess: "rw",
      hwaccess: "none",
      fields: [
        { bits: "31:0" }
      ],
    },
    { name: "Reserved_3_c10",
      desc: "Reserved, implementation defined (32 bits over 64)",
      swaccess: "none",
      hwaccess: "none",
      fields: [
        { bits: "31:0" }
      ],
    },
    { name: "Channel_Flags_c10",
      desc: "Defines wheter interrupts or polling is used for communication",
      swaccess: "rw",
      hwaccess: "none",
      fields: [
        { bits: "31:1" },
        { bits: "0",
          name: "intr_enable",
          desc: "If 1 interruts are used, if 0 polling is used"
        }
      ],
    },
    { name: "Length_c10",
      desc: "Lenght of payload + header",
      swaccess: "rw",
      hwaccess: "none",
      fields: [
        { bits: "31:0" }
      ],
    },
    { name: "Message_Header_c10",
      desc: "Defines which commanad the message contains",
      swaccess: "rw",
      hwaccess: "none",
      fields: [
        { bits: "31:28" },
        { bits: "27:18",
          name: "Token",
          desc: "must be same for the msg responses associated to a msg whith the same header"
        },
        { bits: "17:10",
          name: "Protocol_Id",
          desc: "Identifies to which protocol the command belongs to"
        },
        { bits: "9:8",
          name: "Message_Type",
          desc: "can be 0,1,2,3 depending on the kind of msg to be sent"
        },
        { bits: "7:0",
          name: "Message_Id",
          desc: "unique identifier for each command availabe in the protocol pointed by protocol_id"
        }
      ],
    },
    { name: "Message_Payload_1_c10",
      desc: "memory region dedicated to the parameters of the commands and their returns",
      swaccess: "rw",
      hwaccess: "none",
      fields: [
        { bits: "31:0" }
      ],
    },
    { name: "Doorbell_c10",
      desc: "Rapresents the interrupt to be raised towards the platform",
      swaccess: "rw",
      hwaccess: "hro",
      fields: [
        { bits: "31:1",
          name: "Preserve_Mask",
          desc: "These bits must be constant to 0, not used with just one platform and one agent"
        },
        { bits: "0",
          name: "intr",
          desc: "Interrupt bit"
        }
      ],
    },
    { name:  "Completion_Interrupt_c10",
      desc: "Rapresent the interrupt the platform should raise when it finishes to execute the received command",
      swaccess: "rw",
      hwaccess: "hro",
      fields: [
        { bits: "31:1",
          name: "Preserve_Mask",
          desc: "These bits must be constant to 0, not used with just one platform and one agent"
        },
        { bits: "0",
          name: "intr",
          desc: "Interrupt bit"
        }
      ],
    },
    { name: "Reserved_1_c11",
      desc: "Reserved, must be 0",
      swaccess: "rw",
      hwaccess: "none",
      fields: [
        { bits: "31:0" }
      ],
    },
    { name: "Channel_Status_c11",
      desc: "Indicates which entity has access to the Shared Memory",
      swaccess: "rw",
      hwaccess: "none",
      fields: [
        { bits: "31:2" },
        { bits: "1",
          name: "channel_error",
          desc: "Must be 0 in absence of errors"
        },
        { bits: "0",
          name: "channel_free",
          desc: "If 1 the agent own the channel, if 0 the platform own the channel"
        }
      ],
    },
    { name: "Reserved_2_c11",
      desc: "Reserved, implementation defined (32 bits over 64)",
      swaccess: "rw",
      hwaccess: "none",
      fields: [
        { bits: "31:0" }
      ],
    },
    { name: "Reserved_3_c11",
      desc: "Reserved, implementation defined (32 bits over 64)",
      swaccess: "none",
      hwaccess: "none",
      fields: [
        { bits: "31:0" }
      ],
    },
    { name: "Channel_Flags_c11",
      desc: "Defines wheter interrupts or polling is used for communication",
      swaccess: "rw",
      hwaccess: "none",
      fields: [
        { bits: "31:1" },
        { bits: "0",
          name: "intr_enable",
          desc: "If 1 interruts are used, if 0 polling is used"
        }
      ],
    },
    { name: "Length_c11",
      desc: "Lenght of payload + header",
      swaccess: "rw",
      hwaccess: "none",
      fields: [
        { bits: "31:0" }
      ],
    },
    { name: "Message_Header_c11",
      desc: "Defines which commanad the message contains",
      swaccess: "rw",
      hwaccess: "none",
      fields: [
        { bits: "31:28" },
        { bits: "27:18",
          name: "Token",
          desc: "must be same for the msg responses associated to a msg whith the same header"
        },
        { bits: "17:10",
          name: "Protocol_Id",
          desc: "Identifies to which protocol the command belongs to"
        },
        { bits: "9:8",
          name: "Message_Type",
          desc: "can be 0,1,2,3 depending on the kind of msg to be sent"
        },
        { bits: "7:0",
          name: "Message_Id",
          desc: "unique identifier for each command availabe in the protocol pointed by protocol_id"
        }
      ],
    },
    { name: "Message_Payload_1_c11",
      desc: "memory region dedicated to the parameters of the commands and their returns",
      swaccess: "rw",
      hwaccess: "none",
      fields: [
        { bits: "31:0" }
      ],
    },
    { name: "Doorbell_c11",
      desc: "Rapresents the interrupt to be raised towards the platform",
      swaccess: "rw",
      hwaccess: "hro",
      fields: [
        { bits: "31:1",
          name: "Preserve_Mask",
          desc: "These bits must be constant to 0, not used with just one platform and one agent"
        },
        { bits: "0",
          name: "intr",
          desc: "Interrupt bit"
        }
      ],
    },
    { name:  "Completion_Interrupt_c11",
      desc: "Rapresent the interrupt the platform should raise when it finishes to execute the received command",
      swaccess: "rw",
      hwaccess: "hro",
      fields: [
        { bits: "31:1",
          name: "Preserve_Mask",
          desc: "These bits must be constant to 0, not used with just one platform and one agent"
        },
        { bits: "0",
          name: "intr",
          desc: "Interrupt bit"
        }
      ],
    },
    { name: "Reserved_1_c12",
      desc: "Reserved, must be 0",
      swaccess: "rw",
      hwaccess: "none",
      fields: [
        { bits: "31:0" }
      ],
    },
    { name: "Channel_Status_c12",
      desc: "Indicates which entity has access to the Shared Memory",
      swaccess: "rw",
      hwaccess: "none",
      fields: [
        { bits: "31:2" },
        { bits: "1",
          name: "channel_error",
          desc: "Must be 0 in absence of errors"
        },
        { bits: "0",
          name: "channel_free",
          desc: "If 1 the agent own the channel, if 0 the platform own the channel"
        }
      ],
    },
    { name: "Reserved_2_c12",
      desc: "Reserved, implementation defined (32 bits over 64)",
      swaccess: "rw",
      hwaccess: "none",
      fields: [
        { bits: "31:0" }
      ],
    },
    { name: "Reserved_3_c12",
      desc: "Reserved, implementation defined (32 bits over 64)",
      swaccess: "none",
      hwaccess: "none",
      fields: [
        { bits: "31:0" }
      ],
    },
    { name: "Channel_Flags_c12",
      desc: "Defines wheter interrupts or polling is used for communication",
      swaccess: "rw",
      hwaccess: "none",
      fields: [
        { bits: "31:1" },
        { bits: "0",
          name: "intr_enable",
          desc: "If 1 interruts are used, if 0 polling is used"
        }
      ],
    },
    { name: "Length_c12",
      desc: "Lenght of payload + header",
      swaccess: "rw",
      hwaccess: "none",
      fields: [
        { bits: "31:0" }
      ],
    },
    { name: "Message_Header_c12",
      desc: "Defines which commanad the message contains",
      swaccess: "rw",
      hwaccess: "none",
      fields: [
        { bits: "31:28" },
        { bits: "27:18",
          name: "Token",
          desc: "must be same for the msg responses associated to a msg whith the same header"
        },
        { bits: "17:10",
          name: "Protocol_Id",
          desc: "Identifies to which protocol the command belongs to"
        },
        { bits: "9:8",
          name: "Message_Type",
          desc: "can be 0,1,2,3 depending on the kind of msg to be sent"
        },
        { bits: "7:0",
          name: "Message_Id",
          desc: "unique identifier for each command availabe in the protocol pointed by protocol_id"
        }
      ],
    },
    { name: "Message_Payload_1_c12",
      desc: "memory region dedicated to the parameters of the commands and their returns",
      swaccess: "rw",
      hwaccess: "none",
      fields: [
        { bits: "31:0" }
      ],
    },
    { name: "Doorbell_c12",
      desc: "Rapresents the interrupt to be raised towards the platform",
      swaccess: "rw",
      hwaccess: "hro",
      fields: [
        { bits: "31:1",
          name: "Preserve_Mask",
          desc: "These bits must be constant to 0, not used with just one platform and one agent"
        },
        { bits: "0",
          name: "intr",
          desc: "Interrupt bit"
        }
      ],
    },
    { name:  "Completion_Interrupt_c12",
      desc: "Rapresent the interrupt the platform should raise when it finishes to execute the received command",
      swaccess: "rw",
      hwaccess: "hro",
      fields: [
        { bits: "31:1",
          name: "Preserve_Mask",
          desc: "These bits must be constant to 0, not used with just one platform and one agent"
        },
        { bits: "0",
          name: "intr",
          desc: "Interrupt bit"
        }
      ],
    },
    { name: "Reserved_1_c13",
      desc: "Reserved, must be 0",
      swaccess: "rw",
      hwaccess: "none",
      fields: [
        { bits: "31:0" }
      ],
    },
    { name: "Channel_Status_c13",
      desc: "Indicates which entity has access to the Shared Memory",
      swaccess: "rw",
      hwaccess: "none",
      fields: [
        { bits: "31:2" },
        { bits: "1",
          name: "channel_error",
          desc: "Must be 0 in absence of errors"
        },
        { bits: "0",
          name: "channel_free",
          desc: "If 1 the agent own the channel, if 0 the platform own the channel"
        }
      ],
    },
    { name: "Reserved_2_c13",
      desc: "Reserved, implementation defined (32 bits over 64)",
      swaccess: "rw",
      hwaccess: "none",
      fields: [
        { bits: "31:0" }
      ],
    },
    { name: "Reserved_3_c13",
      desc: "Reserved, implementation defined (32 bits over 64)",
      swaccess: "none",
      hwaccess: "none",
      fields: [
        { bits: "31:0" }
      ],
    },
    { name: "Channel_Flags_c13",
      desc: "Defines wheter interrupts or polling is used for communication",
      swaccess: "rw",
      hwaccess: "none",
      fields: [
        { bits: "31:1" },
        { bits: "0",
          name: "intr_enable",
          desc: "If 1 interruts are used, if 0 polling is used"
        }
      ],
    },
    { name: "Length_c13",
      desc: "Lenght of payload + header",
      swaccess: "rw",
      hwaccess: "none",
      fields: [
        { bits: "31:0" }
      ],
    },
    { name: "Message_Header_c13",
      desc: "Defines which commanad the message contains",
      swaccess: "rw",
      hwaccess: "none",
      fields: [
        { bits: "31:28" },
        { bits: "27:18",
          name: "Token",
          desc: "must be same for the msg responses associated to a msg whith the same header"
        },
        { bits: "17:10",
          name: "Protocol_Id",
          desc: "Identifies to which protocol the command belongs to"
        },
        { bits: "9:8",
          name: "Message_Type",
          desc: "can be 0,1,2,3 depending on the kind of msg to be sent"
        },
        { bits: "7:0",
          name: "Message_Id",
          desc: "unique identifier for each command availabe in the protocol pointed by protocol_id"
        }
      ],
    },
    { name: "Message_Payload_1_c13",
      desc: "memory region dedicated to the parameters of the commands and their returns",
      swaccess: "rw",
      hwaccess: "none",
      fields: [
        { bits: "31:0" }
      ],
    },
    { name: "Doorbell_c13",
      desc: "Rapresents the interrupt to be raised towards the platform",
      swaccess: "rw",
      hwaccess: "hro",
      fields: [
        { bits: "31:1",
          name: "Preserve_Mask",
          desc: "These bits must be constant to 0, not used with just one platform and one agent"
        },
        { bits: "0",
          name: "intr",
          desc: "Interrupt bit"
        }
      ],
    },
    { name:  "Completion_Interrupt_c13",
      desc: "Rapresent the interrupt the platform should raise when it finishes to execute the received command",
      swaccess: "rw",
      hwaccess: "hro",
      fields: [
        { bits: "31:1",
          name: "Preserve_Mask",
          desc: "These bits must be constant to 0, not used with just one platform and one agent"
        },
        { bits: "0",
          name: "intr",
          desc: "Interrupt bit"
        }
      ],
    },
    { name: "Reserved_1_c14",
      desc: "Reserved, must be 0",
      swaccess: "rw",
      hwaccess: "none",
      fields: [
        { bits: "31:0" }
      ],
    },
    { name: "Channel_Status_c14",
      desc: "Indicates which entity has access to the Shared Memory",
      swaccess: "rw",
      hwaccess: "none",
      fields: [
        { bits: "31:2" },
        { bits: "1",
          name: "channel_error",
          desc: "Must be 0 in absence of errors"
        },
        { bits: "0",
          name: "channel_free",
          desc: "If 1 the agent own the channel, if 0 the platform own the channel"
        }
      ],
    },
    { name: "Reserved_2_c14",
      desc: "Reserved, implementation defined (32 bits over 64)",
      swaccess: "rw",
      hwaccess: "none",
      fields: [
        { bits: "31:0" }
      ],
    },
    { name: "Reserved_3_c14",
      desc: "Reserved, implementation defined (32 bits over 64)",
      swaccess: "none",
      hwaccess: "none",
      fields: [
        { bits: "31:0" }
      ],
    },
    { name: "Channel_Flags_c14",
      desc: "Defines wheter interrupts or polling is used for communication",
      swaccess: "rw",
      hwaccess: "none",
      fields: [
        { bits: "31:1" },
        { bits: "0",
          name: "intr_enable",
          desc: "If 1 interruts are used, if 0 polling is used"
        }
      ],
    },
    { name: "Length_c14",
      desc: "Lenght of payload + header",
      swaccess: "rw",
      hwaccess: "none",
      fields: [
        { bits: "31:0" }
      ],
    },
    { name: "Message_Header_c14",
      desc: "Defines which commanad the message contains",
      swaccess: "rw",
      hwaccess: "none",
      fields: [
        { bits: "31:28" },
        { bits: "27:18",
          name: "Token",
          desc: "must be same for the msg responses associated to a msg whith the same header"
        },
        { bits: "17:10",
          name: "Protocol_Id",
          desc: "Identifies to which protocol the command belongs to"
        },
        { bits: "9:8",
          name: "Message_Type",
          desc: "can be 0,1,2,3 depending on the kind of msg to be sent"
        },
        { bits: "7:0",
          name: "Message_Id",
          desc: "unique identifier for each command availabe in the protocol pointed by protocol_id"
        }
      ],
    },
    { name: "Message_Payload_1_c14",
      desc: "memory region dedicated to the parameters of the commands and their returns",
      swaccess: "rw",
      hwaccess: "none",
      fields: [
        { bits: "31:0" }
      ],
    },
    { name: "Doorbell_c14",
      desc: "Rapresents the interrupt to be raised towards the platform",
      swaccess: "rw",
      hwaccess: "hro",
      fields: [
        { bits: "31:1",
          name: "Preserve_Mask",
          desc: "These bits must be constant to 0, not used with just one platform and one agent"
        },
        { bits: "0",
          name: "intr",
          desc: "Interrupt bit"
        }
      ],
    },
    { name:  "Completion_Interrupt_c14",
      desc: "Rapresent the interrupt the platform should raise when it finishes to execute the received command",
      swaccess: "rw",
      hwaccess: "hro",
      fields: [
        { bits: "31:1",
          name: "Preserve_Mask",
          desc: "These bits must be constant to 0, not used with just one platform and one agent"
        },
        { bits: "0",
          name: "intr",
          desc: "Interrupt bit"
        }
      ],
    },
    { name: "Reserved_1_c15",
      desc: "Reserved, must be 0",
      swaccess: "rw",
      hwaccess: "none",
      fields: [
        { bits: "31:0" }
      ],
    },
    { name: "Channel_Status_c15",
      desc: "Indicates which entity has access to the Shared Memory",
      swaccess: "rw",
      hwaccess: "none",
      fields: [
        { bits: "31:2" },
        { bits: "1",
          name: "channel_error",
          desc: "Must be 0 in absence of errors"
        },
        { bits: "0",
          name: "channel_free",
          desc: "If 1 the agent own the channel, if 0 the platform own the channel"
        }
      ],
    },
    { name: "Reserved_2_c15",
      desc: "Reserved, implementation defined (32 bits over 64)",
      swaccess: "rw",
      hwaccess: "none",
      fields: [
        { bits: "31:0" }
      ],
    },
    { name: "Reserved_3_c15",
      desc: "Reserved, implementation defined (32 bits over 64)",
      swaccess: "none",
      hwaccess: "none",
      fields: [
        { bits: "31:0" }
      ],
    },
    { name: "Channel_Flags_c15",
      desc: "Defines wheter interrupts or polling is used for communication",
      swaccess: "rw",
      hwaccess: "none",
      fields: [
        { bits: "31:1" },
        { bits: "0",
          name: "intr_enable",
          desc: "If 1 interruts are used, if 0 polling is used"
        }
      ],
    },
    { name: "Length_c15",
      desc: "Lenght of payload + header",
      swaccess: "rw",
      hwaccess: "none",
      fields: [
        { bits: "31:0" }
      ],
    },
    { name: "Message_Header_c15",
      desc: "Defines which commanad the message contains",
      swaccess: "rw",
      hwaccess: "none",
      fields: [
        { bits: "31:28" },
        { bits: "27:18",
          name: "Token",
          desc: "must be same for the msg responses associated to a msg whith the same header"
        },
        { bits: "17:10",
          name: "Protocol_Id",
          desc: "Identifies to which protocol the command belongs to"
        },
        { bits: "9:8",
          name: "Message_Type",
          desc: "can be 0,1,2,3 depending on the kind of msg to be sent"
        },
        { bits: "7:0",
          name: "Message_Id",
          desc: "unique identifier for each command availabe in the protocol pointed by protocol_id"
        }
      ],
    },
    { name: "Message_Payload_1_c15",
      desc: "memory region dedicated to the parameters of the commands and their returns",
      swaccess: "rw",
      hwaccess: "none",
      fields: [
        { bits: "31:0" }
      ],
    },
    { name: "Doorbell_c15",
      desc: "Rapresents the interrupt to be raised towards the platform",
      swaccess: "rw",
      hwaccess: "hro",
      fields: [
        { bits: "31:1",
          name: "Preserve_Mask",
          desc: "These bits must be constant to 0, not used with just one platform and one agent"
        },
        { bits: "0",
          name: "intr",
          desc: "Interrupt bit"
        }
      ],
    },
    { name:  "Completion_Interrupt_c15",
      desc: "Rapresent the interrupt the platform should raise when it finishes to execute the received command",
      swaccess: "rw",
      hwaccess: "hro",
      fields: [
        { bits: "31:1",
          name: "Preserve_Mask",
          desc: "These bits must be constant to 0, not used with just one platform and one agent"
        },
        { bits: "0",
          name: "intr",
          desc: "Interrupt bit"
        }
      ],
    },
    { name: "Reserved_1_c16",
      desc: "Reserved, must be 0",
      swaccess: "rw",
      hwaccess: "none",
      fields: [
        { bits: "31:0" }
      ],
    },
    { name: "Channel_Status_c16",
      desc: "Indicates which entity has access to the Shared Memory",
      swaccess: "rw",
      hwaccess: "none",
      fields: [
        { bits: "31:2" },
        { bits: "1",
          name: "channel_error",
          desc: "Must be 0 in absence of errors"
        },
        { bits: "0",
          name: "channel_free",
          desc: "If 1 the agent own the channel, if 0 the platform own the channel"
        }
      ],
    },
    { name: "Reserved_2_c16",
      desc: "Reserved, implementation defined (32 bits over 64)",
      swaccess: "rw",
      hwaccess: "none",
      fields: [
        { bits: "31:0" }
      ],
    },
    { name: "Reserved_3_c16",
      desc: "Reserved, implementation defined (32 bits over 64)",
      swaccess: "none",
      hwaccess: "none",
      fields: [
        { bits: "31:0" }
      ],
    },
    { name: "Channel_Flags_c16",
      desc: "Defines wheter interrupts or polling is used for communication",
      swaccess: "rw",
      hwaccess: "none",
      fields: [
        { bits: "31:1" },
        { bits: "0",
          name: "intr_enable",
          desc: "If 1 interruts are used, if 0 polling is used"
        }
      ],
    },
    { name: "Length_c16",
      desc: "Lenght of payload + header",
      swaccess: "rw",
      hwaccess: "none",
      fields: [
        { bits: "31:0" }
      ],
    },
    { name: "Message_Header_c16",
      desc: "Defines which commanad the message contains",
      swaccess: "rw",
      hwaccess: "none",
      fields: [
        { bits: "31:28" },
        { bits: "27:18",
          name: "Token",
          desc: "must be same for the msg responses associated to a msg whith the same header"
        },
        { bits: "17:10",
          name: "Protocol_Id",
          desc: "Identifies to which protocol the command belongs to"
        },
        { bits: "9:8",
          name: "Message_Type",
          desc: "can be 0,1,2,3 depending on the kind of msg to be sent"
        },
        { bits: "7:0",
          name: "Message_Id",
          desc: "unique identifier for each command availabe in the protocol pointed by protocol_id"
        }
      ],
    },
    { name: "Message_Payload_1_c16",
      desc: "memory region dedicated to the parameters of the commands and their returns",
      swaccess: "rw",
      hwaccess: "none",
      fields: [
        { bits: "31:0" }
      ],
    },
    { name: "Doorbell_c16",
      desc: "Rapresents the interrupt to be raised towards the platform",
      swaccess: "rw",
      hwaccess: "hro",
      fields: [
        { bits: "31:1",
          name: "Preserve_Mask",
          desc: "These bits must be constant to 0, not used with just one platform and one agent"
        },
        { bits: "0",
          name: "intr",
          desc: "Interrupt bit"
        }
      ],
    },
    { name:  "Completion_Interrupt_c16",
      desc: "Rapresent the interrupt the platform should raise when it finishes to execute the received command",
      swaccess: "rw",
      hwaccess: "hro",
      fields: [
        { bits: "31:1",
          name: "Preserve_Mask",
          desc: "These bits must be constant to 0, not used with just one platform and one agent"
        },
        { bits: "0",
          name: "intr",
          desc: "Interrupt bit"
        }
      ],
    },
    { name: "Reserved_1_c17",
      desc: "Reserved, must be 0",
      swaccess: "rw",
      hwaccess: "none",
      fields: [
        { bits: "31:0" }
      ],
    },
    { name: "Channel_Status_c17",
      desc: "Indicates which entity has access to the Shared Memory",
      swaccess: "rw",
      hwaccess: "none",
      fields: [
        { bits: "31:2" },
        { bits: "1",
          name: "channel_error",
          desc: "Must be 0 in absence of errors"
        },
        { bits: "0",
          name: "channel_free",
          desc: "If 1 the agent own the channel, if 0 the platform own the channel"
        }
      ],
    },
    { name: "Reserved_2_c17",
      desc: "Reserved, implementation defined (32 bits over 64)",
      swaccess: "rw",
      hwaccess: "none",
      fields: [
        { bits: "31:0" }
      ],
    },
    { name: "Reserved_3_c17",
      desc: "Reserved, implementation defined (32 bits over 64)",
      swaccess: "none",
      hwaccess: "none",
      fields: [
        { bits: "31:0" }
      ],
    },
    { name: "Channel_Flags_c17",
      desc: "Defines wheter interrupts or polling is used for communication",
      swaccess: "rw",
      hwaccess: "none",
      fields: [
        { bits: "31:1" },
        { bits: "0",
          name: "intr_enable",
          desc: "If 1 interruts are used, if 0 polling is used"
        }
      ],
    },
    { name: "Length_c17",
      desc: "Lenght of payload + header",
      swaccess: "rw",
      hwaccess: "none",
      fields: [
        { bits: "31:0" }
      ],
    },
    { name: "Message_Header_c17",
      desc: "Defines which commanad the message contains",
      swaccess: "rw",
      hwaccess: "none",
      fields: [
        { bits: "31:28" },
        { bits: "27:18",
          name: "Token",
          desc: "must be same for the msg responses associated to a msg whith the same header"
        },
        { bits: "17:10",
          name: "Protocol_Id",
          desc: "Identifies to which protocol the command belongs to"
        },
        { bits: "9:8",
          name: "Message_Type",
          desc: "can be 0,1,2,3 depending on the kind of msg to be sent"
        },
        { bits: "7:0",
          name: "Message_Id",
          desc: "unique identifier for each command availabe in the protocol pointed by protocol_id"
        }
      ],
    },
    { name: "Message_Payload_1_c17",
      desc: "memory region dedicated to the parameters of the commands and their returns",
      swaccess: "rw",
      hwaccess: "none",
      fields: [
        { bits: "31:0" }
      ],
    },
    { name: "Doorbell_c17",
      desc: "Rapresents the interrupt to be raised towards the platform",
      swaccess: "rw",
      hwaccess: "hro",
      fields: [
        { bits: "31:1",
          name: "Preserve_Mask",
          desc: "These bits must be constant to 0, not used with just one platform and one agent"
        },
        { bits: "0",
          name: "intr",
          desc: "Interrupt bit"
        }
      ],
    },
    { name:  "Completion_Interrupt_c17",
      desc: "Rapresent the interrupt the platform should raise when it finishes to execute the received command",
      swaccess: "rw",
      hwaccess: "hro",
      fields: [
        { bits: "31:1",
          name: "Preserve_Mask",
          desc: "These bits must be constant to 0, not used with just one platform and one agent"
        },
        { bits: "0",
          name: "intr",
          desc: "Interrupt bit"
        }
      ],
    },
    { name: "Reserved_1_c18",
      desc: "Reserved, must be 0",
      swaccess: "rw",
      hwaccess: "none",
      fields: [
        { bits: "31:0" }
      ],
    },
    { name: "Channel_Status_c18",
      desc: "Indicates which entity has access to the Shared Memory",
      swaccess: "rw",
      hwaccess: "none",
      fields: [
        { bits: "31:2" },
        { bits: "1",
          name: "channel_error",
          desc: "Must be 0 in absence of errors"
        },
        { bits: "0",
          name: "channel_free",
          desc: "If 1 the agent own the channel, if 0 the platform own the channel"
        }
      ],
    },
    { name: "Reserved_2_c18",
      desc: "Reserved, implementation defined (32 bits over 64)",
      swaccess: "rw",
      hwaccess: "none",
      fields: [
        { bits: "31:0" }
      ],
    },
    { name: "Reserved_3_c18",
      desc: "Reserved, implementation defined (32 bits over 64)",
      swaccess: "none",
      hwaccess: "none",
      fields: [
        { bits: "31:0" }
      ],
    },
    { name: "Channel_Flags_c18",
      desc: "Defines wheter interrupts or polling is used for communication",
      swaccess: "rw",
      hwaccess: "none",
      fields: [
        { bits: "31:1" },
        { bits: "0",
          name: "intr_enable",
          desc: "If 1 interruts are used, if 0 polling is used"
        }
      ],
    },
    { name: "Length_c18",
      desc: "Lenght of payload + header",
      swaccess: "rw",
      hwaccess: "none",
      fields: [
        { bits: "31:0" }
      ],
    },
    { name: "Message_Header_c18",
      desc: "Defines which commanad the message contains",
      swaccess: "rw",
      hwaccess: "none",
      fields: [
        { bits: "31:28" },
        { bits: "27:18",
          name: "Token",
          desc: "must be same for the msg responses associated to a msg whith the same header"
        },
        { bits: "17:10",
          name: "Protocol_Id",
          desc: "Identifies to which protocol the command belongs to"
        },
        { bits: "9:8",
          name: "Message_Type",
          desc: "can be 0,1,2,3 depending on the kind of msg to be sent"
        },
        { bits: "7:0",
          name: "Message_Id",
          desc: "unique identifier for each command availabe in the protocol pointed by protocol_id"
        }
      ],
    },
    { name: "Message_Payload_1_c18",
      desc: "memory region dedicated to the parameters of the commands and their returns",
      swaccess: "rw",
      hwaccess: "none",
      fields: [
        { bits: "31:0" }
      ],
    },
    { name: "Doorbell_c18",
      desc: "Rapresents the interrupt to be raised towards the platform",
      swaccess: "rw",
      hwaccess: "hro",
      fields: [
        { bits: "31:1",
          name: "Preserve_Mask",
          desc: "These bits must be constant to 0, not used with just one platform and one agent"
        },
        { bits: "0",
          name: "intr",
          desc: "Interrupt bit"
        }
      ],
    },
    { name:  "Completion_Interrupt_c18",
      desc: "Rapresent the interrupt the platform should raise when it finishes to execute the received command",
      swaccess: "rw",
      hwaccess: "hro",
      fields: [
        { bits: "31:1",
          name: "Preserve_Mask",
          desc: "These bits must be constant to 0, not used with just one platform and one agent"
        },
        { bits: "0",
          name: "intr",
          desc: "Interrupt bit"
        }
      ],
    },
    { name: "Reserved_1_c19",
      desc: "Reserved, must be 0",
      swaccess: "rw",
      hwaccess: "none",
      fields: [
        { bits: "31:0" }
      ],
    },
    { name: "Channel_Status_c19",
      desc: "Indicates which entity has access to the Shared Memory",
      swaccess: "rw",
      hwaccess: "none",
      fields: [
        { bits: "31:2" },
        { bits: "1",
          name: "channel_error",
          desc: "Must be 0 in absence of errors"
        },
        { bits: "0",
          name: "channel_free",
          desc: "If 1 the agent own the channel, if 0 the platform own the channel"
        }
      ],
    },
    { name: "Reserved_2_c19",
      desc: "Reserved, implementation defined (32 bits over 64)",
      swaccess: "rw",
      hwaccess: "none",
      fields: [
        { bits: "31:0" }
      ],
    },
    { name: "Reserved_3_c19",
      desc: "Reserved, implementation defined (32 bits over 64)",
      swaccess: "none",
      hwaccess: "none",
      fields: [
        { bits: "31:0" }
      ],
    },
    { name: "Channel_Flags_c19",
      desc: "Defines wheter interrupts or polling is used for communication",
      swaccess: "rw",
      hwaccess: "none",
      fields: [
        { bits: "31:1" },
        { bits: "0",
          name: "intr_enable",
          desc: "If 1 interruts are used, if 0 polling is used"
        }
      ],
    },
    { name: "Length_c19",
      desc: "Lenght of payload + header",
      swaccess: "rw",
      hwaccess: "none",
      fields: [
        { bits: "31:0" }
      ],
    },
    { name: "Message_Header_c19",
      desc: "Defines which commanad the message contains",
      swaccess: "rw",
      hwaccess: "none",
      fields: [
        { bits: "31:28" },
        { bits: "27:18",
          name: "Token",
          desc: "must be same for the msg responses associated to a msg whith the same header"
        },
        { bits: "17:10",
          name: "Protocol_Id",
          desc: "Identifies to which protocol the command belongs to"
        },
        { bits: "9:8",
          name: "Message_Type",
          desc: "can be 0,1,2,3 depending on the kind of msg to be sent"
        },
        { bits: "7:0",
          name: "Message_Id",
          desc: "unique identifier for each command availabe in the protocol pointed by protocol_id"
        }
      ],
    },
    { name: "Message_Payload_1_c19",
      desc: "memory region dedicated to the parameters of the commands and their returns",
      swaccess: "rw",
      hwaccess: "none",
      fields: [
        { bits: "31:0" }
      ],
    },
    { name: "Doorbell_c19",
      desc: "Rapresents the interrupt to be raised towards the platform",
      swaccess: "rw",
      hwaccess: "hro",
      fields: [
        { bits: "31:1",
          name: "Preserve_Mask",
          desc: "These bits must be constant to 0, not used with just one platform and one agent"
        },
        { bits: "0",
          name: "intr",
          desc: "Interrupt bit"
        }
      ],
    },
    { name:  "Completion_Interrupt_c19",
      desc: "Rapresent the interrupt the platform should raise when it finishes to execute the received command",
      swaccess: "rw",
      hwaccess: "hro",
      fields: [
        { bits: "31:1",
          name: "Preserve_Mask",
          desc: "These bits must be constant to 0, not used with just one platform and one agent"
        },
        { bits: "0",
          name: "intr",
          desc: "Interrupt bit"
        }
      ],
    },
    { name: "Reserved_1_c20",
      desc: "Reserved, must be 0",
      swaccess: "rw",
      hwaccess: "none",
      fields: [
        { bits: "31:0" }
      ],
    },
    { name: "Channel_Status_c20",
      desc: "Indicates which entity has access to the Shared Memory",
      swaccess: "rw",
      hwaccess: "none",
      fields: [
        { bits: "31:2" },
        { bits: "1",
          name: "channel_error",
          desc: "Must be 0 in absence of errors"
        },
        { bits: "0",
          name: "channel_free",
          desc: "If 1 the agent own the channel, if 0 the platform own the channel"
        }
      ],
    },
    { name: "Reserved_2_c20",
      desc: "Reserved, implementation defined (32 bits over 64)",
      swaccess: "rw",
      hwaccess: "none",
      fields: [
        { bits: "31:0" }
      ],
    },
    { name: "Reserved_3_c20",
      desc: "Reserved, implementation defined (32 bits over 64)",
      swaccess: "none",
      hwaccess: "none",
      fields: [
        { bits: "31:0" }
      ],
    },
    { name: "Channel_Flags_c20",
      desc: "Defines wheter interrupts or polling is used for communication",
      swaccess: "rw",
      hwaccess: "none",
      fields: [
        { bits: "31:1" },
        { bits: "0",
          name: "intr_enable",
          desc: "If 1 interruts are used, if 0 polling is used"
        }
      ],
    },
    { name: "Length_c20",
      desc: "Lenght of payload + header",
      swaccess: "rw",
      hwaccess: "none",
      fields: [
        { bits: "31:0" }
      ],
    },
    { name: "Message_Header_c20",
      desc: "Defines which commanad the message contains",
      swaccess: "rw",
      hwaccess: "none",
      fields: [
        { bits: "31:28" },
        { bits: "27:18",
          name: "Token",
          desc: "must be same for the msg responses associated to a msg whith the same header"
        },
        { bits: "17:10",
          name: "Protocol_Id",
          desc: "Identifies to which protocol the command belongs to"
        },
        { bits: "9:8",
          name: "Message_Type",
          desc: "can be 0,1,2,3 depending on the kind of msg to be sent"
        },
        { bits: "7:0",
          name: "Message_Id",
          desc: "unique identifier for each command availabe in the protocol pointed by protocol_id"
        }
      ],
    },
    { name: "Message_Payload_1_c20",
      desc: "memory region dedicated to the parameters of the commands and their returns",
      swaccess: "rw",
      hwaccess: "none",
      fields: [
        { bits: "31:0" }
      ],
    },
    { name: "Doorbell_c20",
      desc: "Rapresents the interrupt to be raised towards the platform",
      swaccess: "rw",
      hwaccess: "hro",
      fields: [
        { bits: "31:1",
          name: "Preserve_Mask",
          desc: "These bits must be constant to 0, not used with just one platform and one agent"
        },
        { bits: "0",
          name: "intr",
          desc: "Interrupt bit"
        }
      ],
    },
    { name:  "Completion_Interrupt_c20",
      desc: "Rapresent the interrupt the platform should raise when it finishes to execute the received command",
      swaccess: "rw",
      hwaccess: "hro",
      fields: [
        { bits: "31:1",
          name: "Preserve_Mask",
          desc: "These bits must be constant to 0, not used with just one platform and one agent"
        },
        { bits: "0",
          name: "intr",
          desc: "Interrupt bit"
        }
      ],
    },
    { name: "Reserved_1_c21",
      desc: "Reserved, must be 0",
      swaccess: "rw",
      hwaccess: "none",
      fields: [
        { bits: "31:0" }
      ],
    },
    { name: "Channel_Status_c21",
      desc: "Indicates which entity has access to the Shared Memory",
      swaccess: "rw",
      hwaccess: "none",
      fields: [
        { bits: "31:2" },
        { bits: "1",
          name: "channel_error",
          desc: "Must be 0 in absence of errors"
        },
        { bits: "0",
          name: "channel_free",
          desc: "If 1 the agent own the channel, if 0 the platform own the channel"
        }
      ],
    },
    { name: "Reserved_2_c21",
      desc: "Reserved, implementation defined (32 bits over 64)",
      swaccess: "rw",
      hwaccess: "none",
      fields: [
        { bits: "31:0" }
      ],
    },
    { name: "Reserved_3_c21",
      desc: "Reserved, implementation defined (32 bits over 64)",
      swaccess: "none",
      hwaccess: "none",
      fields: [
        { bits: "31:0" }
      ],
    },
    { name: "Channel_Flags_c21",
      desc: "Defines wheter interrupts or polling is used for communication",
      swaccess: "rw",
      hwaccess: "none",
      fields: [
        { bits: "31:1" },
        { bits: "0",
          name: "intr_enable",
          desc: "If 1 interruts are used, if 0 polling is used"
        }
      ],
    },
    { name: "Length_c21",
      desc: "Lenght of payload + header",
      swaccess: "rw",
      hwaccess: "none",
      fields: [
        { bits: "31:0" }
      ],
    },
    { name: "Message_Header_c21",
      desc: "Defines which commanad the message contains",
      swaccess: "rw",
      hwaccess: "none",
      fields: [
        { bits: "31:28" },
        { bits: "27:18",
          name: "Token",
          desc: "must be same for the msg responses associated to a msg whith the same header"
        },
        { bits: "17:10",
          name: "Protocol_Id",
          desc: "Identifies to which protocol the command belongs to"
        },
        { bits: "9:8",
          name: "Message_Type",
          desc: "can be 0,1,2,3 depending on the kind of msg to be sent"
        },
        { bits: "7:0",
          name: "Message_Id",
          desc: "unique identifier for each command availabe in the protocol pointed by protocol_id"
        }
      ],
    },
    { name: "Message_Payload_1_c21",
      desc: "memory region dedicated to the parameters of the commands and their returns",
      swaccess: "rw",
      hwaccess: "none",
      fields: [
        { bits: "31:0" }
      ],
    },
    { name: "Doorbell_c21",
      desc: "Rapresents the interrupt to be raised towards the platform",
      swaccess: "rw",
      hwaccess: "hro",
      fields: [
        { bits: "31:1",
          name: "Preserve_Mask",
          desc: "These bits must be constant to 0, not used with just one platform and one agent"
        },
        { bits: "0",
          name: "intr",
          desc: "Interrupt bit"
        }
      ],
    },
    { name:  "Completion_Interrupt_c21",
      desc: "Rapresent the interrupt the platform should raise when it finishes to execute the received command",
      swaccess: "rw",
      hwaccess: "hro",
      fields: [
        { bits: "31:1",
          name: "Preserve_Mask",
          desc: "These bits must be constant to 0, not used with just one platform and one agent"
        },
        { bits: "0",
          name: "intr",
          desc: "Interrupt bit"
        }
      ],
    },
    { name: "Reserved_1_c22",
      desc: "Reserved, must be 0",
      swaccess: "rw",
      hwaccess: "none",
      fields: [
        { bits: "31:0" }
      ],
    },
    { name: "Channel_Status_c22",
      desc: "Indicates which entity has access to the Shared Memory",
      swaccess: "rw",
      hwaccess: "none",
      fields: [
        { bits: "31:2" },
        { bits: "1",
          name: "channel_error",
          desc: "Must be 0 in absence of errors"
        },
        { bits: "0",
          name: "channel_free",
          desc: "If 1 the agent own the channel, if 0 the platform own the channel"
        }
      ],
    },
    { name: "Reserved_2_c22",
      desc: "Reserved, implementation defined (32 bits over 64)",
      swaccess: "rw",
      hwaccess: "none",
      fields: [
        { bits: "31:0" }
      ],
    },
    { name: "Reserved_3_c22",
      desc: "Reserved, implementation defined (32 bits over 64)",
      swaccess: "none",
      hwaccess: "none",
      fields: [
        { bits: "31:0" }
      ],
    },
    { name: "Channel_Flags_c22",
      desc: "Defines wheter interrupts or polling is used for communication",
      swaccess: "rw",
      hwaccess: "none",
      fields: [
        { bits: "31:1" },
        { bits: "0",
          name: "intr_enable",
          desc: "If 1 interruts are used, if 0 polling is used"
        }
      ],
    },
    { name: "Length_c22",
      desc: "Lenght of payload + header",
      swaccess: "rw",
      hwaccess: "none",
      fields: [
        { bits: "31:0" }
      ],
    },
    { name: "Message_Header_c22",
      desc: "Defines which commanad the message contains",
      swaccess: "rw",
      hwaccess: "none",
      fields: [
        { bits: "31:28" },
        { bits: "27:18",
          name: "Token",
          desc: "must be same for the msg responses associated to a msg whith the same header"
        },
        { bits: "17:10",
          name: "Protocol_Id",
          desc: "Identifies to which protocol the command belongs to"
        },
        { bits: "9:8",
          name: "Message_Type",
          desc: "can be 0,1,2,3 depending on the kind of msg to be sent"
        },
        { bits: "7:0",
          name: "Message_Id",
          desc: "unique identifier for each command availabe in the protocol pointed by protocol_id"
        }
      ],
    },
    { name: "Message_Payload_1_c22",
      desc: "memory region dedicated to the parameters of the commands and their returns",
      swaccess: "rw",
      hwaccess: "none",
      fields: [
        { bits: "31:0" }
      ],
    },
    { name: "Doorbell_c22",
      desc: "Rapresents the interrupt to be raised towards the platform",
      swaccess: "rw",
      hwaccess: "hro",
      fields: [
        { bits: "31:1",
          name: "Preserve_Mask",
          desc: "These bits must be constant to 0, not used with just one platform and one agent"
        },
        { bits: "0",
          name: "intr",
          desc: "Interrupt bit"
        }
      ],
    },
    { name:  "Completion_Interrupt_c22",
      desc: "Rapresent the interrupt the platform should raise when it finishes to execute the received command",
      swaccess: "rw",
      hwaccess: "hro",
      fields: [
        { bits: "31:1",
          name: "Preserve_Mask",
          desc: "These bits must be constant to 0, not used with just one platform and one agent"
        },
        { bits: "0",
          name: "intr",
          desc: "Interrupt bit"
        }
      ],
    },
    { name: "Reserved_1_c23",
      desc: "Reserved, must be 0",
      swaccess: "rw",
      hwaccess: "none",
      fields: [
        { bits: "31:0" }
      ],
    },
    { name: "Channel_Status_c23",
      desc: "Indicates which entity has access to the Shared Memory",
      swaccess: "rw",
      hwaccess: "none",
      fields: [
        { bits: "31:2" },
        { bits: "1",
          name: "channel_error",
          desc: "Must be 0 in absence of errors"
        },
        { bits: "0",
          name: "channel_free",
          desc: "If 1 the agent own the channel, if 0 the platform own the channel"
        }
      ],
    },
    { name: "Reserved_2_c23",
      desc: "Reserved, implementation defined (32 bits over 64)",
      swaccess: "rw",
      hwaccess: "none",
      fields: [
        { bits: "31:0" }
      ],
    },
    { name: "Reserved_3_c23",
      desc: "Reserved, implementation defined (32 bits over 64)",
      swaccess: "none",
      hwaccess: "none",
      fields: [
        { bits: "31:0" }
      ],
    },
    { name: "Channel_Flags_c23",
      desc: "Defines wheter interrupts or polling is used for communication",
      swaccess: "rw",
      hwaccess: "none",
      fields: [
        { bits: "31:1" },
        { bits: "0",
          name: "intr_enable",
          desc: "If 1 interruts are used, if 0 polling is used"
        }
      ],
    },
    { name: "Length_c23",
      desc: "Lenght of payload + header",
      swaccess: "rw",
      hwaccess: "none",
      fields: [
        { bits: "31:0" }
      ],
    },
    { name: "Message_Header_c23",
      desc: "Defines which commanad the message contains",
      swaccess: "rw",
      hwaccess: "none",
      fields: [
        { bits: "31:28" },
        { bits: "27:18",
          name: "Token",
          desc: "must be same for the msg responses associated to a msg whith the same header"
        },
        { bits: "17:10",
          name: "Protocol_Id",
          desc: "Identifies to which protocol the command belongs to"
        },
        { bits: "9:8",
          name: "Message_Type",
          desc: "can be 0,1,2,3 depending on the kind of msg to be sent"
        },
        { bits: "7:0",
          name: "Message_Id",
          desc: "unique identifier for each command availabe in the protocol pointed by protocol_id"
        }
      ],
    },
    { name: "Message_Payload_1_c23",
      desc: "memory region dedicated to the parameters of the commands and their returns",
      swaccess: "rw",
      hwaccess: "none",
      fields: [
        { bits: "31:0" }
      ],
    },
    { name: "Doorbell_c23",
      desc: "Rapresents the interrupt to be raised towards the platform",
      swaccess: "rw",
      hwaccess: "hro",
      fields: [
        { bits: "31:1",
          name: "Preserve_Mask",
          desc: "These bits must be constant to 0, not used with just one platform and one agent"
        },
        { bits: "0",
          name: "intr",
          desc: "Interrupt bit"
        }
      ],
    },
    { name:  "Completion_Interrupt_c23",
      desc: "Rapresent the interrupt the platform should raise when it finishes to execute the received command",
      swaccess: "rw",
      hwaccess: "hro",
      fields: [
        { bits: "31:1",
          name: "Preserve_Mask",
          desc: "These bits must be constant to 0, not used with just one platform and one agent"
        },
        { bits: "0",
          name: "intr",
          desc: "Interrupt bit"
        }
      ],
    },
    { name: "Reserved_1_c24",
      desc: "Reserved, must be 0",
      swaccess: "rw",
      hwaccess: "none",
      fields: [
        { bits: "31:0" }
      ],
    },
    { name: "Channel_Status_c24",
      desc: "Indicates which entity has access to the Shared Memory",
      swaccess: "rw",
      hwaccess: "none",
      fields: [
        { bits: "31:2" },
        { bits: "1",
          name: "channel_error",
          desc: "Must be 0 in absence of errors"
        },
        { bits: "0",
          name: "channel_free",
          desc: "If 1 the agent own the channel, if 0 the platform own the channel"
        }
      ],
    },
    { name: "Reserved_2_c24",
      desc: "Reserved, implementation defined (32 bits over 64)",
      swaccess: "rw",
      hwaccess: "none",
      fields: [
        { bits: "31:0" }
      ],
    },
    { name: "Reserved_3_c24",
      desc: "Reserved, implementation defined (32 bits over 64)",
      swaccess: "none",
      hwaccess: "none",
      fields: [
        { bits: "31:0" }
      ],
    },
    { name: "Channel_Flags_c24",
      desc: "Defines wheter interrupts or polling is used for communication",
      swaccess: "rw",
      hwaccess: "none",
      fields: [
        { bits: "31:1" },
        { bits: "0",
          name: "intr_enable",
          desc: "If 1 interruts are used, if 0 polling is used"
        }
      ],
    },
    { name: "Length_c24",
      desc: "Lenght of payload + header",
      swaccess: "rw",
      hwaccess: "none",
      fields: [
        { bits: "31:0" }
      ],
    },
    { name: "Message_Header_c24",
      desc: "Defines which commanad the message contains",
      swaccess: "rw",
      hwaccess: "none",
      fields: [
        { bits: "31:28" },
        { bits: "27:18",
          name: "Token",
          desc: "must be same for the msg responses associated to a msg whith the same header"
        },
        { bits: "17:10",
          name: "Protocol_Id",
          desc: "Identifies to which protocol the command belongs to"
        },
        { bits: "9:8",
          name: "Message_Type",
          desc: "can be 0,1,2,3 depending on the kind of msg to be sent"
        },
        { bits: "7:0",
          name: "Message_Id",
          desc: "unique identifier for each command availabe in the protocol pointed by protocol_id"
        }
      ],
    },
    { name: "Message_Payload_1_c24",
      desc: "memory region dedicated to the parameters of the commands and their returns",
      swaccess: "rw",
      hwaccess: "none",
      fields: [
        { bits: "31:0" }
      ],
    },
    { name: "Doorbell_c24",
      desc: "Rapresents the interrupt to be raised towards the platform",
      swaccess: "rw",
      hwaccess: "hro",
      fields: [
        { bits: "31:1",
          name: "Preserve_Mask",
          desc: "These bits must be constant to 0, not used with just one platform and one agent"
        },
        { bits: "0",
          name: "intr",
          desc: "Interrupt bit"
        }
      ],
    },
    { name:  "Completion_Interrupt_c24",
      desc: "Rapresent the interrupt the platform should raise when it finishes to execute the received command",
      swaccess: "rw",
      hwaccess: "hro",
      fields: [
        { bits: "31:1",
          name: "Preserve_Mask",
          desc: "These bits must be constant to 0, not used with just one platform and one agent"
        },
        { bits: "0",
          name: "intr",
          desc: "Interrupt bit"
        }
      ],
    },
    { name: "Reserved_1_c25",
      desc: "Reserved, must be 0",
      swaccess: "rw",
      hwaccess: "none",
      fields: [
        { bits: "31:0" }
      ],
    },
    { name: "Channel_Status_c25",
      desc: "Indicates which entity has access to the Shared Memory",
      swaccess: "rw",
      hwaccess: "none",
      fields: [
        { bits: "31:2" },
        { bits: "1",
          name: "channel_error",
          desc: "Must be 0 in absence of errors"
        },
        { bits: "0",
          name: "channel_free",
          desc: "If 1 the agent own the channel, if 0 the platform own the channel"
        }
      ],
    },
    { name: "Reserved_2_c25",
      desc: "Reserved, implementation defined (32 bits over 64)",
      swaccess: "rw",
      hwaccess: "none",
      fields: [
        { bits: "31:0" }
      ],
    },
    { name: "Reserved_3_c25",
      desc: "Reserved, implementation defined (32 bits over 64)",
      swaccess: "none",
      hwaccess: "none",
      fields: [
        { bits: "31:0" }
      ],
    },
    { name: "Channel_Flags_c25",
      desc: "Defines wheter interrupts or polling is used for communication",
      swaccess: "rw",
      hwaccess: "none",
      fields: [
        { bits: "31:1" },
        { bits: "0",
          name: "intr_enable",
          desc: "If 1 interruts are used, if 0 polling is used"
        }
      ],
    },
    { name: "Length_c25",
      desc: "Lenght of payload + header",
      swaccess: "rw",
      hwaccess: "none",
      fields: [
        { bits: "31:0" }
      ],
    },
    { name: "Message_Header_c25",
      desc: "Defines which commanad the message contains",
      swaccess: "rw",
      hwaccess: "none",
      fields: [
        { bits: "31:28" },
        { bits: "27:18",
          name: "Token",
          desc: "must be same for the msg responses associated to a msg whith the same header"
        },
        { bits: "17:10",
          name: "Protocol_Id",
          desc: "Identifies to which protocol the command belongs to"
        },
        { bits: "9:8",
          name: "Message_Type",
          desc: "can be 0,1,2,3 depending on the kind of msg to be sent"
        },
        { bits: "7:0",
          name: "Message_Id",
          desc: "unique identifier for each command availabe in the protocol pointed by protocol_id"
        }
      ],
    },
    { name: "Message_Payload_1_c25",
      desc: "memory region dedicated to the parameters of the commands and their returns",
      swaccess: "rw",
      hwaccess: "none",
      fields: [
        { bits: "31:0" }
      ],
    },
    { name: "Doorbell_c25",
      desc: "Rapresents the interrupt to be raised towards the platform",
      swaccess: "rw",
      hwaccess: "hro",
      fields: [
        { bits: "31:1",
          name: "Preserve_Mask",
          desc: "These bits must be constant to 0, not used with just one platform and one agent"
        },
        { bits: "0",
          name: "intr",
          desc: "Interrupt bit"
        }
      ],
    },
    { name:  "Completion_Interrupt_c25",
      desc: "Rapresent the interrupt the platform should raise when it finishes to execute the received command",
      swaccess: "rw",
      hwaccess: "hro",
      fields: [
        { bits: "31:1",
          name: "Preserve_Mask",
          desc: "These bits must be constant to 0, not used with just one platform and one agent"
        },
        { bits: "0",
          name: "intr",
          desc: "Interrupt bit"
        }
      ],
    },
    { name: "Reserved_1_c26",
      desc: "Reserved, must be 0",
      swaccess: "rw",
      hwaccess: "none",
      fields: [
        { bits: "31:0" }
      ],
    },
    { name: "Channel_Status_c26",
      desc: "Indicates which entity has access to the Shared Memory",
      swaccess: "rw",
      hwaccess: "none",
      fields: [
        { bits: "31:2" },
        { bits: "1",
          name: "channel_error",
          desc: "Must be 0 in absence of errors"
        },
        { bits: "0",
          name: "channel_free",
          desc: "If 1 the agent own the channel, if 0 the platform own the channel"
        }
      ],
    },
    { name: "Reserved_2_c26",
      desc: "Reserved, implementation defined (32 bits over 64)",
      swaccess: "rw",
      hwaccess: "none",
      fields: [
        { bits: "31:0" }
      ],
    },
    { name: "Reserved_3_c26",
      desc: "Reserved, implementation defined (32 bits over 64)",
      swaccess: "none",
      hwaccess: "none",
      fields: [
        { bits: "31:0" }
      ],
    },
    { name: "Channel_Flags_c26",
      desc: "Defines wheter interrupts or polling is used for communication",
      swaccess: "rw",
      hwaccess: "none",
      fields: [
        { bits: "31:1" },
        { bits: "0",
          name: "intr_enable",
          desc: "If 1 interruts are used, if 0 polling is used"
        }
      ],
    },
    { name: "Length_c26",
      desc: "Lenght of payload + header",
      swaccess: "rw",
      hwaccess: "none",
      fields: [
        { bits: "31:0" }
      ],
    },
    { name: "Message_Header_c26",
      desc: "Defines which commanad the message contains",
      swaccess: "rw",
      hwaccess: "none",
      fields: [
        { bits: "31:28" },
        { bits: "27:18",
          name: "Token",
          desc: "must be same for the msg responses associated to a msg whith the same header"
        },
        { bits: "17:10",
          name: "Protocol_Id",
          desc: "Identifies to which protocol the command belongs to"
        },
        { bits: "9:8",
          name: "Message_Type",
          desc: "can be 0,1,2,3 depending on the kind of msg to be sent"
        },
        { bits: "7:0",
          name: "Message_Id",
          desc: "unique identifier for each command availabe in the protocol pointed by protocol_id"
        }
      ],
    },
    { name: "Message_Payload_1_c26",
      desc: "memory region dedicated to the parameters of the commands and their returns",
      swaccess: "rw",
      hwaccess: "none",
      fields: [
        { bits: "31:0" }
      ],
    },
    { name: "Doorbell_c26",
      desc: "Rapresents the interrupt to be raised towards the platform",
      swaccess: "rw",
      hwaccess: "hro",
      fields: [
        { bits: "31:1",
          name: "Preserve_Mask",
          desc: "These bits must be constant to 0, not used with just one platform and one agent"
        },
        { bits: "0",
          name: "intr",
          desc: "Interrupt bit"
        }
      ],
    },
    { name:  "Completion_Interrupt_c26",
      desc: "Rapresent the interrupt the platform should raise when it finishes to execute the received command",
      swaccess: "rw",
      hwaccess: "hro",
      fields: [
        { bits: "31:1",
          name: "Preserve_Mask",
          desc: "These bits must be constant to 0, not used with just one platform and one agent"
        },
        { bits: "0",
          name: "intr",
          desc: "Interrupt bit"
        }
      ],
    },
    { name: "Reserved_1_c27",
      desc: "Reserved, must be 0",
      swaccess: "rw",
      hwaccess: "none",
      fields: [
        { bits: "31:0" }
      ],
    },
    { name: "Channel_Status_c27",
      desc: "Indicates which entity has access to the Shared Memory",
      swaccess: "rw",
      hwaccess: "none",
      fields: [
        { bits: "31:2" },
        { bits: "1",
          name: "channel_error",
          desc: "Must be 0 in absence of errors"
        },
        { bits: "0",
          name: "channel_free",
          desc: "If 1 the agent own the channel, if 0 the platform own the channel"
        }
      ],
    },
    { name: "Reserved_2_c27",
      desc: "Reserved, implementation defined (32 bits over 64)",
      swaccess: "rw",
      hwaccess: "none",
      fields: [
        { bits: "31:0" }
      ],
    },
    { name: "Reserved_3_c27",
      desc: "Reserved, implementation defined (32 bits over 64)",
      swaccess: "none",
      hwaccess: "none",
      fields: [
        { bits: "31:0" }
      ],
    },
    { name: "Channel_Flags_c27",
      desc: "Defines wheter interrupts or polling is used for communication",
      swaccess: "rw",
      hwaccess: "none",
      fields: [
        { bits: "31:1" },
        { bits: "0",
          name: "intr_enable",
          desc: "If 1 interruts are used, if 0 polling is used"
        }
      ],
    },
    { name: "Length_c27",
      desc: "Lenght of payload + header",
      swaccess: "rw",
      hwaccess: "none",
      fields: [
        { bits: "31:0" }
      ],
    },
    { name: "Message_Header_c27",
      desc: "Defines which commanad the message contains",
      swaccess: "rw",
      hwaccess: "none",
      fields: [
        { bits: "31:28" },
        { bits: "27:18",
          name: "Token",
          desc: "must be same for the msg responses associated to a msg whith the same header"
        },
        { bits: "17:10",
          name: "Protocol_Id",
          desc: "Identifies to which protocol the command belongs to"
        },
        { bits: "9:8",
          name: "Message_Type",
          desc: "can be 0,1,2,3 depending on the kind of msg to be sent"
        },
        { bits: "7:0",
          name: "Message_Id",
          desc: "unique identifier for each command availabe in the protocol pointed by protocol_id"
        }
      ],
    },
    { name: "Message_Payload_1_c27",
      desc: "memory region dedicated to the parameters of the commands and their returns",
      swaccess: "rw",
      hwaccess: "none",
      fields: [
        { bits: "31:0" }
      ],
    },
    { name: "Doorbell_c27",
      desc: "Rapresents the interrupt to be raised towards the platform",
      swaccess: "rw",
      hwaccess: "hro",
      fields: [
        { bits: "31:1",
          name: "Preserve_Mask",
          desc: "These bits must be constant to 0, not used with just one platform and one agent"
        },
        { bits: "0",
          name: "intr",
          desc: "Interrupt bit"
        }
      ],
    },
    { name:  "Completion_Interrupt_c27",
      desc: "Rapresent the interrupt the platform should raise when it finishes to execute the received command",
      swaccess: "rw",
      hwaccess: "hro",
      fields: [
        { bits: "31:1",
          name: "Preserve_Mask",
          desc: "These bits must be constant to 0, not used with just one platform and one agent"
        },
        { bits: "0",
          name: "intr",
          desc: "Interrupt bit"
        }
      ],
    },
    { name: "Reserved_1_c28",
      desc: "Reserved, must be 0",
      swaccess: "rw",
      hwaccess: "none",
      fields: [
        { bits: "31:0" }
      ],
    },
    { name: "Channel_Status_c28",
      desc: "Indicates which entity has access to the Shared Memory",
      swaccess: "rw",
      hwaccess: "none",
      fields: [
        { bits: "31:2" },
        { bits: "1",
          name: "channel_error",
          desc: "Must be 0 in absence of errors"
        },
        { bits: "0",
          name: "channel_free",
          desc: "If 1 the agent own the channel, if 0 the platform own the channel"
        }
      ],
    },
    { name: "Reserved_2_c28",
      desc: "Reserved, implementation defined (32 bits over 64)",
      swaccess: "rw",
      hwaccess: "none",
      fields: [
        { bits: "31:0" }
      ],
    },
    { name: "Reserved_3_c28",
      desc: "Reserved, implementation defined (32 bits over 64)",
      swaccess: "none",
      hwaccess: "none",
      fields: [
        { bits: "31:0" }
      ],
    },
    { name: "Channel_Flags_c28",
      desc: "Defines wheter interrupts or polling is used for communication",
      swaccess: "rw",
      hwaccess: "none",
      fields: [
        { bits: "31:1" },
        { bits: "0",
          name: "intr_enable",
          desc: "If 1 interruts are used, if 0 polling is used"
        }
      ],
    },
    { name: "Length_c28",
      desc: "Lenght of payload + header",
      swaccess: "rw",
      hwaccess: "none",
      fields: [
        { bits: "31:0" }
      ],
    },
    { name: "Message_Header_c28",
      desc: "Defines which commanad the message contains",
      swaccess: "rw",
      hwaccess: "none",
      fields: [
        { bits: "31:28" },
        { bits: "27:18",
          name: "Token",
          desc: "must be same for the msg responses associated to a msg whith the same header"
        },
        { bits: "17:10",
          name: "Protocol_Id",
          desc: "Identifies to which protocol the command belongs to"
        },
        { bits: "9:8",
          name: "Message_Type",
          desc: "can be 0,1,2,3 depending on the kind of msg to be sent"
        },
        { bits: "7:0",
          name: "Message_Id",
          desc: "unique identifier for each command availabe in the protocol pointed by protocol_id"
        }
      ],
    },
    { name: "Message_Payload_1_c28",
      desc: "memory region dedicated to the parameters of the commands and their returns",
      swaccess: "rw",
      hwaccess: "none",
      fields: [
        { bits: "31:0" }
      ],
    },
    { name: "Doorbell_c28",
      desc: "Rapresents the interrupt to be raised towards the platform",
      swaccess: "rw",
      hwaccess: "hro",
      fields: [
        { bits: "31:1",
          name: "Preserve_Mask",
          desc: "These bits must be constant to 0, not used with just one platform and one agent"
        },
        { bits: "0",
          name: "intr",
          desc: "Interrupt bit"
        }
      ],
    },
    { name:  "Completion_Interrupt_c28",
      desc: "Rapresent the interrupt the platform should raise when it finishes to execute the received command",
      swaccess: "rw",
      hwaccess: "hro",
      fields: [
        { bits: "31:1",
          name: "Preserve_Mask",
          desc: "These bits must be constant to 0, not used with just one platform and one agent"
        },
        { bits: "0",
          name: "intr",
          desc: "Interrupt bit"
        }
      ],
    },
    { name: "Reserved_1_c29",
      desc: "Reserved, must be 0",
      swaccess: "rw",
      hwaccess: "none",
      fields: [
        { bits: "31:0" }
      ],
    },
    { name: "Channel_Status_c29",
      desc: "Indicates which entity has access to the Shared Memory",
      swaccess: "rw",
      hwaccess: "none",
      fields: [
        { bits: "31:2" },
        { bits: "1",
          name: "channel_error",
          desc: "Must be 0 in absence of errors"
        },
        { bits: "0",
          name: "channel_free",
          desc: "If 1 the agent own the channel, if 0 the platform own the channel"
        }
      ],
    },
    { name: "Reserved_2_c29",
      desc: "Reserved, implementation defined (32 bits over 64)",
      swaccess: "rw",
      hwaccess: "none",
      fields: [
        { bits: "31:0" }
      ],
    },
    { name: "Reserved_3_c29",
      desc: "Reserved, implementation defined (32 bits over 64)",
      swaccess: "none",
      hwaccess: "none",
      fields: [
        { bits: "31:0" }
      ],
    },
    { name: "Channel_Flags_c29",
      desc: "Defines wheter interrupts or polling is used for communication",
      swaccess: "rw",
      hwaccess: "none",
      fields: [
        { bits: "31:1" },
        { bits: "0",
          name: "intr_enable",
          desc: "If 1 interruts are used, if 0 polling is used"
        }
      ],
    },
    { name: "Length_c29",
      desc: "Lenght of payload + header",
      swaccess: "rw",
      hwaccess: "none",
      fields: [
        { bits: "31:0" }
      ],
    },
    { name: "Message_Header_c29",
      desc: "Defines which commanad the message contains",
      swaccess: "rw",
      hwaccess: "none",
      fields: [
        { bits: "31:28" },
        { bits: "27:18",
          name: "Token",
          desc: "must be same for the msg responses associated to a msg whith the same header"
        },
        { bits: "17:10",
          name: "Protocol_Id",
          desc: "Identifies to which protocol the command belongs to"
        },
        { bits: "9:8",
          name: "Message_Type",
          desc: "can be 0,1,2,3 depending on the kind of msg to be sent"
        },
        { bits: "7:0",
          name: "Message_Id",
          desc: "unique identifier for each command availabe in the protocol pointed by protocol_id"
        }
      ],
    },
    { name: "Message_Payload_1_c29",
      desc: "memory region dedicated to the parameters of the commands and their returns",
      swaccess: "rw",
      hwaccess: "none",
      fields: [
        { bits: "31:0" }
      ],
    },
    { name: "Doorbell_c29",
      desc: "Rapresents the interrupt to be raised towards the platform",
      swaccess: "rw",
      hwaccess: "hro",
      fields: [
        { bits: "31:1",
          name: "Preserve_Mask",
          desc: "These bits must be constant to 0, not used with just one platform and one agent"
        },
        { bits: "0",
          name: "intr",
          desc: "Interrupt bit"
        }
      ],
    },
    { name:  "Completion_Interrupt_c29",
      desc: "Rapresent the interrupt the platform should raise when it finishes to execute the received command",
      swaccess: "rw",
      hwaccess: "hro",
      fields: [
        { bits: "31:1",
          name: "Preserve_Mask",
          desc: "These bits must be constant to 0, not used with just one platform and one agent"
        },
        { bits: "0",
          name: "intr",
          desc: "Interrupt bit"
        }
      ],
    },
    { name: "Reserved_1_c30",
      desc: "Reserved, must be 0",
      swaccess: "rw",
      hwaccess: "none",
      fields: [
        { bits: "31:0" }
      ],
    },
    { name: "Channel_Status_c30",
      desc: "Indicates which entity has access to the Shared Memory",
      swaccess: "rw",
      hwaccess: "none",
      fields: [
        { bits: "31:2" },
        { bits: "1",
          name: "channel_error",
          desc: "Must be 0 in absence of errors"
        },
        { bits: "0",
          name: "channel_free",
          desc: "If 1 the agent own the channel, if 0 the platform own the channel"
        }
      ],
    },
    { name: "Reserved_2_c30",
      desc: "Reserved, implementation defined (32 bits over 64)",
      swaccess: "rw",
      hwaccess: "none",
      fields: [
        { bits: "31:0" }
      ],
    },
    { name: "Reserved_3_c30",
      desc: "Reserved, implementation defined (32 bits over 64)",
      swaccess: "none",
      hwaccess: "none",
      fields: [
        { bits: "31:0" }
      ],
    },
    { name: "Channel_Flags_c30",
      desc: "Defines wheter interrupts or polling is used for communication",
      swaccess: "rw",
      hwaccess: "none",
      fields: [
        { bits: "31:1" },
        { bits: "0",
          name: "intr_enable",
          desc: "If 1 interruts are used, if 0 polling is used"
        }
      ],
    },
    { name: "Length_c30",
      desc: "Lenght of payload + header",
      swaccess: "rw",
      hwaccess: "none",
      fields: [
        { bits: "31:0" }
      ],
    },
    { name: "Message_Header_c30",
      desc: "Defines which commanad the message contains",
      swaccess: "rw",
      hwaccess: "none",
      fields: [
        { bits: "31:28" },
        { bits: "27:18",
          name: "Token",
          desc: "must be same for the msg responses associated to a msg whith the same header"
        },
        { bits: "17:10",
          name: "Protocol_Id",
          desc: "Identifies to which protocol the command belongs to"
        },
        { bits: "9:8",
          name: "Message_Type",
          desc: "can be 0,1,2,3 depending on the kind of msg to be sent"
        },
        { bits: "7:0",
          name: "Message_Id",
          desc: "unique identifier for each command availabe in the protocol pointed by protocol_id"
        }
      ],
    },
    { name: "Message_Payload_1_c30",
      desc: "memory region dedicated to the parameters of the commands and their returns",
      swaccess: "rw",
      hwaccess: "none",
      fields: [
        { bits: "31:0" }
      ],
    },
    { name: "Doorbell_c30",
      desc: "Rapresents the interrupt to be raised towards the platform",
      swaccess: "rw",
      hwaccess: "hro",
      fields: [
        { bits: "31:1",
          name: "Preserve_Mask",
          desc: "These bits must be constant to 0, not used with just one platform and one agent"
        },
        { bits: "0",
          name: "intr",
          desc: "Interrupt bit"
        }
      ],
    },
    { name:  "Completion_Interrupt_c30",
      desc: "Rapresent the interrupt the platform should raise when it finishes to execute the received command",
      swaccess: "rw",
      hwaccess: "hro",
      fields: [
        { bits: "31:1",
          name: "Preserve_Mask",
          desc: "These bits must be constant to 0, not used with just one platform and one agent"
        },
        { bits: "0",
          name: "intr",
          desc: "Interrupt bit"
        }
      ],
    },
    { name: "Reserved_1_c31",
      desc: "Reserved, must be 0",
      swaccess: "rw",
      hwaccess: "none",
      fields: [
        { bits: "31:0" }
      ],
    },
    { name: "Channel_Status_c31",
      desc: "Indicates which entity has access to the Shared Memory",
      swaccess: "rw",
      hwaccess: "none",
      fields: [
        { bits: "31:2" },
        { bits: "1",
          name: "channel_error",
          desc: "Must be 0 in absence of errors"
        },
        { bits: "0",
          name: "channel_free",
          desc: "If 1 the agent own the channel, if 0 the platform own the channel"
        }
      ],
    },
    { name: "Reserved_2_c31",
      desc: "Reserved, implementation defined (32 bits over 64)",
      swaccess: "rw",
      hwaccess: "none",
      fields: [
        { bits: "31:0" }
      ],
    },
    { name: "Reserved_3_c31",
      desc: "Reserved, implementation defined (32 bits over 64)",
      swaccess: "none",
      hwaccess: "none",
      fields: [
        { bits: "31:0" }
      ],
    },
    { name: "Channel_Flags_c31",
      desc: "Defines wheter interrupts or polling is used for communication",
      swaccess: "rw",
      hwaccess: "none",
      fields: [
        { bits: "31:1" },
        { bits: "0",
          name: "intr_enable",
          desc: "If 1 interruts are used, if 0 polling is used"
        }
      ],
    },
    { name: "Length_c31",
      desc: "Lenght of payload + header",
      swaccess: "rw",
      hwaccess: "none",
      fields: [
        { bits: "31:0" }
      ],
    },
    { name: "Message_Header_c31",
      desc: "Defines which commanad the message contains",
      swaccess: "rw",
      hwaccess: "none",
      fields: [
        { bits: "31:28" },
        { bits: "27:18",
          name: "Token",
          desc: "must be same for the msg responses associated to a msg whith the same header"
        },
        { bits: "17:10",
          name: "Protocol_Id",
          desc: "Identifies to which protocol the command belongs to"
        },
        { bits: "9:8",
          name: "Message_Type",
          desc: "can be 0,1,2,3 depending on the kind of msg to be sent"
        },
        { bits: "7:0",
          name: "Message_Id",
          desc: "unique identifier for each command availabe in the protocol pointed by protocol_id"
        }
      ],
    },
    { name: "Message_Payload_1_c31",
      desc: "memory region dedicated to the parameters of the commands and their returns",
      swaccess: "rw",
      hwaccess: "none",
      fields: [
        { bits: "31:0" }
      ],
    },
    { name: "Doorbell_c31",
      desc: "Rapresents the interrupt to be raised towards the platform",
      swaccess: "rw",
      hwaccess: "hro",
      fields: [
        { bits: "31:1",
          name: "Preserve_Mask",
          desc: "These bits must be constant to 0, not used with just one platform and one agent"
        },
        { bits: "0",
          name: "intr",
          desc: "Interrupt bit"
        }
      ],
    },
    { name:  "Completion_Interrupt_c31",
      desc: "Rapresent the interrupt the platform should raise when it finishes to execute the received command",
      swaccess: "rw",
      hwaccess: "hro",
      fields: [
        { bits: "31:1",
          name: "Preserve_Mask",
          desc: "These bits must be constant to 0, not used with just one platform and one agent"
        },
        { bits: "0",
          name: "intr",
          desc: "Interrupt bit"
        }
      ],
    },
    { name: "Reserved_1_c32",
      desc: "Reserved, must be 0",
      swaccess: "rw",
      hwaccess: "none",
      fields: [
        { bits: "31:0" }
      ],
    },
    { name: "Channel_Status_c32",
      desc: "Indicates which entity has access to the Shared Memory",
      swaccess: "rw",
      hwaccess: "none",
      fields: [
        { bits: "31:2" },
        { bits: "1",
          name: "channel_error",
          desc: "Must be 0 in absence of errors"
        },
        { bits: "0",
          name: "channel_free",
          desc: "If 1 the agent own the channel, if 0 the platform own the channel"
        }
      ],
    },
    { name: "Reserved_2_c32",
      desc: "Reserved, implementation defined (32 bits over 64)",
      swaccess: "rw",
      hwaccess: "none",
      fields: [
        { bits: "31:0" }
      ],
    },
    { name: "Reserved_3_c32",
      desc: "Reserved, implementation defined (32 bits over 64)",
      swaccess: "none",
      hwaccess: "none",
      fields: [
        { bits: "31:0" }
      ],
    },
    { name: "Channel_Flags_c32",
      desc: "Defines wheter interrupts or polling is used for communication",
      swaccess: "rw",
      hwaccess: "none",
      fields: [
        { bits: "31:1" },
        { bits: "0",
          name: "intr_enable",
          desc: "If 1 interruts are used, if 0 polling is used"
        }
      ],
    },
    { name: "Length_c32",
      desc: "Lenght of payload + header",
      swaccess: "rw",
      hwaccess: "none",
      fields: [
        { bits: "31:0" }
      ],
    },
    { name: "Message_Header_c32",
      desc: "Defines which commanad the message contains",
      swaccess: "rw",
      hwaccess: "none",
      fields: [
        { bits: "31:28" },
        { bits: "27:18",
          name: "Token",
          desc: "must be same for the msg responses associated to a msg whith the same header"
        },
        { bits: "17:10",
          name: "Protocol_Id",
          desc: "Identifies to which protocol the command belongs to"
        },
        { bits: "9:8",
          name: "Message_Type",
          desc: "can be 0,1,2,3 depending on the kind of msg to be sent"
        },
        { bits: "7:0",
          name: "Message_Id",
          desc: "unique identifier for each command availabe in the protocol pointed by protocol_id"
        }
      ],
    },
    { name: "Message_Payload_1_c32",
      desc: "memory region dedicated to the parameters of the commands and their returns",
      swaccess: "rw",
      hwaccess: "none",
      fields: [
        { bits: "31:0" }
      ],
    },
    { name: "Doorbell_c32",
      desc: "Rapresents the interrupt to be raised towards the platform",
      swaccess: "rw",
      hwaccess: "hro",
      fields: [
        { bits: "31:1",
          name: "Preserve_Mask",
          desc: "These bits must be constant to 0, not used with just one platform and one agent"
        },
        { bits: "0",
          name: "intr",
          desc: "Interrupt bit"
        }
      ],
    },
    { name:  "Completion_Interrupt_c32",
      desc: "Rapresent the interrupt the platform should raise when it finishes to execute the received command",
      swaccess: "rw",
      hwaccess: "hro",
      fields: [
        { bits: "31:1",
          name: "Preserve_Mask",
          desc: "These bits must be constant to 0, not used with just one platform and one agent"
        },
        { bits: "0",
          name: "intr",
          desc: "Interrupt bit"
        }
      ],
    },
    { name: "Reserved_1_c33",
      desc: "Reserved, must be 0",
      swaccess: "rw",
      hwaccess: "none",
      fields: [
        { bits: "31:0" }
      ],
    },
    { name: "Channel_Status_c33",
      desc: "Indicates which entity has access to the Shared Memory",
      swaccess: "rw",
      hwaccess: "none",
      fields: [
        { bits: "31:2" },
        { bits: "1",
          name: "channel_error",
          desc: "Must be 0 in absence of errors"
        },
        { bits: "0",
          name: "channel_free",
          desc: "If 1 the agent own the channel, if 0 the platform own the channel"
        }
      ],
    },
    { name: "Reserved_2_c33",
      desc: "Reserved, implementation defined (32 bits over 64)",
      swaccess: "rw",
      hwaccess: "none",
      fields: [
        { bits: "31:0" }
      ],
    },
    { name: "Reserved_3_c33",
      desc: "Reserved, implementation defined (32 bits over 64)",
      swaccess: "none",
      hwaccess: "none",
      fields: [
        { bits: "31:0" }
      ],
    },
    { name: "Channel_Flags_c33",
      desc: "Defines wheter interrupts or polling is used for communication",
      swaccess: "rw",
      hwaccess: "none",
      fields: [
        { bits: "31:1" },
        { bits: "0",
          name: "intr_enable",
          desc: "If 1 interruts are used, if 0 polling is used"
        }
      ],
    },
    { name: "Length_c33",
      desc: "Lenght of payload + header",
      swaccess: "rw",
      hwaccess: "none",
      fields: [
        { bits: "31:0" }
      ],
    },
    { name: "Message_Header_c33",
      desc: "Defines which commanad the message contains",
      swaccess: "rw",
      hwaccess: "none",
      fields: [
        { bits: "31:28" },
        { bits: "27:18",
          name: "Token",
          desc: "must be same for the msg responses associated to a msg whith the same header"
        },
        { bits: "17:10",
          name: "Protocol_Id",
          desc: "Identifies to which protocol the command belongs to"
        },
        { bits: "9:8",
          name: "Message_Type",
          desc: "can be 0,1,2,3 depending on the kind of msg to be sent"
        },
        { bits: "7:0",
          name: "Message_Id",
          desc: "unique identifier for each command availabe in the protocol pointed by protocol_id"
        }
      ],
    },
    { name: "Message_Payload_1_c33",
      desc: "memory region dedicated to the parameters of the commands and their returns",
      swaccess: "rw",
      hwaccess: "none",
      fields: [
        { bits: "31:0" }
      ],
    },
    { name: "Doorbell_c33",
      desc: "Rapresents the interrupt to be raised towards the platform",
      swaccess: "rw",
      hwaccess: "hro",
      fields: [
        { bits: "31:1",
          name: "Preserve_Mask",
          desc: "These bits must be constant to 0, not used with just one platform and one agent"
        },
        { bits: "0",
          name: "intr",
          desc: "Interrupt bit"
        }
      ],
    },
    { name:  "Completion_Interrupt_c33",
      desc: "Rapresent the interrupt the platform should raise when it finishes to execute the received command",
      swaccess: "rw",
      hwaccess: "hro",
      fields: [
        { bits: "31:1",
          name: "Preserve_Mask",
          desc: "These bits must be constant to 0, not used with just one platform and one agent"
        },
        { bits: "0",
          name: "intr",
          desc: "Interrupt bit"
        }
      ],
    },
    { name: "Reserved_1_c34",
      desc: "Reserved, must be 0",
      swaccess: "rw",
      hwaccess: "none",
      fields: [
        { bits: "31:0" }
      ],
    },
    { name: "Channel_Status_c34",
      desc: "Indicates which entity has access to the Shared Memory",
      swaccess: "rw",
      hwaccess: "none",
      fields: [
        { bits: "31:2" },
        { bits: "1",
          name: "channel_error",
          desc: "Must be 0 in absence of errors"
        },
        { bits: "0",
          name: "channel_free",
          desc: "If 1 the agent own the channel, if 0 the platform own the channel"
        }
      ],
    },
    { name: "Reserved_2_c34",
      desc: "Reserved, implementation defined (32 bits over 64)",
      swaccess: "rw",
      hwaccess: "none",
      fields: [
        { bits: "31:0" }
      ],
    },
    { name: "Reserved_3_c34",
      desc: "Reserved, implementation defined (32 bits over 64)",
      swaccess: "none",
      hwaccess: "none",
      fields: [
        { bits: "31:0" }
      ],
    },
    { name: "Channel_Flags_c34",
      desc: "Defines wheter interrupts or polling is used for communication",
      swaccess: "rw",
      hwaccess: "none",
      fields: [
        { bits: "31:1" },
        { bits: "0",
          name: "intr_enable",
          desc: "If 1 interruts are used, if 0 polling is used"
        }
      ],
    },
    { name: "Length_c34",
      desc: "Lenght of payload + header",
      swaccess: "rw",
      hwaccess: "none",
      fields: [
        { bits: "31:0" }
      ],
    },
    { name: "Message_Header_c34",
      desc: "Defines which commanad the message contains",
      swaccess: "rw",
      hwaccess: "none",
      fields: [
        { bits: "31:28" },
        { bits: "27:18",
          name: "Token",
          desc: "must be same for the msg responses associated to a msg whith the same header"
        },
        { bits: "17:10",
          name: "Protocol_Id",
          desc: "Identifies to which protocol the command belongs to"
        },
        { bits: "9:8",
          name: "Message_Type",
          desc: "can be 0,1,2,3 depending on the kind of msg to be sent"
        },
        { bits: "7:0",
          name: "Message_Id",
          desc: "unique identifier for each command availabe in the protocol pointed by protocol_id"
        }
      ],
    },
    { name: "Message_Payload_1_c34",
      desc: "memory region dedicated to the parameters of the commands and their returns",
      swaccess: "rw",
      hwaccess: "none",
      fields: [
        { bits: "31:0" }
      ],
    },
    { name: "Doorbell_c34",
      desc: "Rapresents the interrupt to be raised towards the platform",
      swaccess: "rw",
      hwaccess: "hro",
      fields: [
        { bits: "31:1",
          name: "Preserve_Mask",
          desc: "These bits must be constant to 0, not used with just one platform and one agent"
        },
        { bits: "0",
          name: "intr",
          desc: "Interrupt bit"
        }
      ],
    },
    { name:  "Completion_Interrupt_c34",
      desc: "Rapresent the interrupt the platform should raise when it finishes to execute the received command",
      swaccess: "rw",
      hwaccess: "hro",
      fields: [
        { bits: "31:1",
          name: "Preserve_Mask",
          desc: "These bits must be constant to 0, not used with just one platform and one agent"
        },
        { bits: "0",
          name: "intr",
          desc: "Interrupt bit"
        }
      ],
    },
    { name: "Reserved_1_c35",
      desc: "Reserved, must be 0",
      swaccess: "rw",
      hwaccess: "none",
      fields: [
        { bits: "31:0" }
      ],
    },
    { name: "Channel_Status_c35",
      desc: "Indicates which entity has access to the Shared Memory",
      swaccess: "rw",
      hwaccess: "none",
      fields: [
        { bits: "31:2" },
        { bits: "1",
          name: "channel_error",
          desc: "Must be 0 in absence of errors"
        },
        { bits: "0",
          name: "channel_free",
          desc: "If 1 the agent own the channel, if 0 the platform own the channel"
        }
      ],
    },
    { name: "Reserved_2_c35",
      desc: "Reserved, implementation defined (32 bits over 64)",
      swaccess: "rw",
      hwaccess: "none",
      fields: [
        { bits: "31:0" }
      ],
    },
    { name: "Reserved_3_c35",
      desc: "Reserved, implementation defined (32 bits over 64)",
      swaccess: "none",
      hwaccess: "none",
      fields: [
        { bits: "31:0" }
      ],
    },
    { name: "Channel_Flags_c35",
      desc: "Defines wheter interrupts or polling is used for communication",
      swaccess: "rw",
      hwaccess: "none",
      fields: [
        { bits: "31:1" },
        { bits: "0",
          name: "intr_enable",
          desc: "If 1 interruts are used, if 0 polling is used"
        }
      ],
    },
    { name: "Length_c35",
      desc: "Lenght of payload + header",
      swaccess: "rw",
      hwaccess: "none",
      fields: [
        { bits: "31:0" }
      ],
    },
    { name: "Message_Header_c35",
      desc: "Defines which commanad the message contains",
      swaccess: "rw",
      hwaccess: "none",
      fields: [
        { bits: "31:28" },
        { bits: "27:18",
          name: "Token",
          desc: "must be same for the msg responses associated to a msg whith the same header"
        },
        { bits: "17:10",
          name: "Protocol_Id",
          desc: "Identifies to which protocol the command belongs to"
        },
        { bits: "9:8",
          name: "Message_Type",
          desc: "can be 0,1,2,3 depending on the kind of msg to be sent"
        },
        { bits: "7:0",
          name: "Message_Id",
          desc: "unique identifier for each command availabe in the protocol pointed by protocol_id"
        }
      ],
    },
    { name: "Message_Payload_1_c35",
      desc: "memory region dedicated to the parameters of the commands and their returns",
      swaccess: "rw",
      hwaccess: "none",
      fields: [
        { bits: "31:0" }
      ],
    },
    { name: "Doorbell_c35",
      desc: "Rapresents the interrupt to be raised towards the platform",
      swaccess: "rw",
      hwaccess: "hro",
      fields: [
        { bits: "31:1",
          name: "Preserve_Mask",
          desc: "These bits must be constant to 0, not used with just one platform and one agent"
        },
        { bits: "0",
          name: "intr",
          desc: "Interrupt bit"
        }
      ],
    },
    { name:  "Completion_Interrupt_c35",
      desc: "Rapresent the interrupt the platform should raise when it finishes to execute the received command",
      swaccess: "rw",
      hwaccess: "hro",
      fields: [
        { bits: "31:1",
          name: "Preserve_Mask",
          desc: "These bits must be constant to 0, not used with just one platform and one agent"
        },
        { bits: "0",
          name: "intr",
          desc: "Interrupt bit"
        }
      ],
    },
    { name: "Reserved_1_c36",
      desc: "Reserved, must be 0",
      swaccess: "rw",
      hwaccess: "none",
      fields: [
        { bits: "31:0" }
      ],
    },
    { name: "Channel_Status_c36",
      desc: "Indicates which entity has access to the Shared Memory",
      swaccess: "rw",
      hwaccess: "none",
      fields: [
        { bits: "31:2" },
        { bits: "1",
          name: "channel_error",
          desc: "Must be 0 in absence of errors"
        },
        { bits: "0",
          name: "channel_free",
          desc: "If 1 the agent own the channel, if 0 the platform own the channel"
        }
      ],
    },
    { name: "Reserved_2_c36",
      desc: "Reserved, implementation defined (32 bits over 64)",
      swaccess: "rw",
      hwaccess: "none",
      fields: [
        { bits: "31:0" }
      ],
    },
    { name: "Reserved_3_c36",
      desc: "Reserved, implementation defined (32 bits over 64)",
      swaccess: "none",
      hwaccess: "none",
      fields: [
        { bits: "31:0" }
      ],
    },
    { name: "Channel_Flags_c36",
      desc: "Defines wheter interrupts or polling is used for communication",
      swaccess: "rw",
      hwaccess: "none",
      fields: [
        { bits: "31:1" },
        { bits: "0",
          name: "intr_enable",
          desc: "If 1 interruts are used, if 0 polling is used"
        }
      ],
    },
    { name: "Length_c36",
      desc: "Lenght of payload + header",
      swaccess: "rw",
      hwaccess: "none",
      fields: [
        { bits: "31:0" }
      ],
    },
    { name: "Message_Header_c36",
      desc: "Defines which commanad the message contains",
      swaccess: "rw",
      hwaccess: "none",
      fields: [
        { bits: "31:28" },
        { bits: "27:18",
          name: "Token",
          desc: "must be same for the msg responses associated to a msg whith the same header"
        },
        { bits: "17:10",
          name: "Protocol_Id",
          desc: "Identifies to which protocol the command belongs to"
        },
        { bits: "9:8",
          name: "Message_Type",
          desc: "can be 0,1,2,3 depending on the kind of msg to be sent"
        },
        { bits: "7:0",
          name: "Message_Id",
          desc: "unique identifier for each command availabe in the protocol pointed by protocol_id"
        }
      ],
    },
    { name: "Message_Payload_1_c36",
      desc: "memory region dedicated to the parameters of the commands and their returns",
      swaccess: "rw",
      hwaccess: "none",
      fields: [
        { bits: "31:0" }
      ],
    },
    { name: "Doorbell_c36",
      desc: "Rapresents the interrupt to be raised towards the platform",
      swaccess: "rw",
      hwaccess: "hro",
      fields: [
        { bits: "31:1",
          name: "Preserve_Mask",
          desc: "These bits must be constant to 0, not used with just one platform and one agent"
        },
        { bits: "0",
          name: "intr",
          desc: "Interrupt bit"
        }
      ],
    },
    { name:  "Completion_Interrupt_c36",
      desc: "Rapresent the interrupt the platform should raise when it finishes to execute the received command",
      swaccess: "rw",
      hwaccess: "hro",
      fields: [
        { bits: "31:1",
          name: "Preserve_Mask",
          desc: "These bits must be constant to 0, not used with just one platform and one agent"
        },
        { bits: "0",
          name: "intr",
          desc: "Interrupt bit"
        }
      ],
    },
    { name: "Reserved_1_c37",
      desc: "Reserved, must be 0",
      swaccess: "rw",
      hwaccess: "none",
      fields: [
        { bits: "31:0" }
      ],
    },
    { name: "Channel_Status_c37",
      desc: "Indicates which entity has access to the Shared Memory",
      swaccess: "rw",
      hwaccess: "none",
      fields: [
        { bits: "31:2" },
        { bits: "1",
          name: "channel_error",
          desc: "Must be 0 in absence of errors"
        },
        { bits: "0",
          name: "channel_free",
          desc: "If 1 the agent own the channel, if 0 the platform own the channel"
        }
      ],
    },
    { name: "Reserved_2_c37",
      desc: "Reserved, implementation defined (32 bits over 64)",
      swaccess: "rw",
      hwaccess: "none",
      fields: [
        { bits: "31:0" }
      ],
    },
    { name: "Reserved_3_c37",
      desc: "Reserved, implementation defined (32 bits over 64)",
      swaccess: "none",
      hwaccess: "none",
      fields: [
        { bits: "31:0" }
      ],
    },
    { name: "Channel_Flags_c37",
      desc: "Defines wheter interrupts or polling is used for communication",
      swaccess: "rw",
      hwaccess: "none",
      fields: [
        { bits: "31:1" },
        { bits: "0",
          name: "intr_enable",
          desc: "If 1 interruts are used, if 0 polling is used"
        }
      ],
    },
    { name: "Length_c37",
      desc: "Lenght of payload + header",
      swaccess: "rw",
      hwaccess: "none",
      fields: [
        { bits: "31:0" }
      ],
    },
    { name: "Message_Header_c37",
      desc: "Defines which commanad the message contains",
      swaccess: "rw",
      hwaccess: "none",
      fields: [
        { bits: "31:28" },
        { bits: "27:18",
          name: "Token",
          desc: "must be same for the msg responses associated to a msg whith the same header"
        },
        { bits: "17:10",
          name: "Protocol_Id",
          desc: "Identifies to which protocol the command belongs to"
        },
        { bits: "9:8",
          name: "Message_Type",
          desc: "can be 0,1,2,3 depending on the kind of msg to be sent"
        },
        { bits: "7:0",
          name: "Message_Id",
          desc: "unique identifier for each command availabe in the protocol pointed by protocol_id"
        }
      ],
    },
    { name: "Message_Payload_1_c37",
      desc: "memory region dedicated to the parameters of the commands and their returns",
      swaccess: "rw",
      hwaccess: "none",
      fields: [
        { bits: "31:0" }
      ],
    },
    { name: "Doorbell_c37",
      desc: "Rapresents the interrupt to be raised towards the platform",
      swaccess: "rw",
      hwaccess: "hro",
      fields: [
        { bits: "31:1",
          name: "Preserve_Mask",
          desc: "These bits must be constant to 0, not used with just one platform and one agent"
        },
        { bits: "0",
          name: "intr",
          desc: "Interrupt bit"
        }
      ],
    },
    { name:  "Completion_Interrupt_c37",
      desc: "Rapresent the interrupt the platform should raise when it finishes to execute the received command",
      swaccess: "rw",
      hwaccess: "hro",
      fields: [
        { bits: "31:1",
          name: "Preserve_Mask",
          desc: "These bits must be constant to 0, not used with just one platform and one agent"
        },
        { bits: "0",
          name: "intr",
          desc: "Interrupt bit"
        }
      ],
    },
    { name: "Reserved_1_c38",
      desc: "Reserved, must be 0",
      swaccess: "rw",
      hwaccess: "none",
      fields: [
        { bits: "31:0" }
      ],
    },
    { name: "Channel_Status_c38",
      desc: "Indicates which entity has access to the Shared Memory",
      swaccess: "rw",
      hwaccess: "none",
      fields: [
        { bits: "31:2" },
        { bits: "1",
          name: "channel_error",
          desc: "Must be 0 in absence of errors"
        },
        { bits: "0",
          name: "channel_free",
          desc: "If 1 the agent own the channel, if 0 the platform own the channel"
        }
      ],
    },
    { name: "Reserved_2_c38",
      desc: "Reserved, implementation defined (32 bits over 64)",
      swaccess: "rw",
      hwaccess: "none",
      fields: [
        { bits: "31:0" }
      ],
    },
    { name: "Reserved_3_c38",
      desc: "Reserved, implementation defined (32 bits over 64)",
      swaccess: "none",
      hwaccess: "none",
      fields: [
        { bits: "31:0" }
      ],
    },
    { name: "Channel_Flags_c38",
      desc: "Defines wheter interrupts or polling is used for communication",
      swaccess: "rw",
      hwaccess: "none",
      fields: [
        { bits: "31:1" },
        { bits: "0",
          name: "intr_enable",
          desc: "If 1 interruts are used, if 0 polling is used"
        }
      ],
    },
    { name: "Length_c38",
      desc: "Lenght of payload + header",
      swaccess: "rw",
      hwaccess: "none",
      fields: [
        { bits: "31:0" }
      ],
    },
    { name: "Message_Header_c38",
      desc: "Defines which commanad the message contains",
      swaccess: "rw",
      hwaccess: "none",
      fields: [
        { bits: "31:28" },
        { bits: "27:18",
          name: "Token",
          desc: "must be same for the msg responses associated to a msg whith the same header"
        },
        { bits: "17:10",
          name: "Protocol_Id",
          desc: "Identifies to which protocol the command belongs to"
        },
        { bits: "9:8",
          name: "Message_Type",
          desc: "can be 0,1,2,3 depending on the kind of msg to be sent"
        },
        { bits: "7:0",
          name: "Message_Id",
          desc: "unique identifier for each command availabe in the protocol pointed by protocol_id"
        }
      ],
    },
    { name: "Message_Payload_1_c38",
      desc: "memory region dedicated to the parameters of the commands and their returns",
      swaccess: "rw",
      hwaccess: "none",
      fields: [
        { bits: "31:0" }
      ],
    },
    { name: "Doorbell_c38",
      desc: "Rapresents the interrupt to be raised towards the platform",
      swaccess: "rw",
      hwaccess: "hro",
      fields: [
        { bits: "31:1",
          name: "Preserve_Mask",
          desc: "These bits must be constant to 0, not used with just one platform and one agent"
        },
        { bits: "0",
          name: "intr",
          desc: "Interrupt bit"
        }
      ],
    },
    { name:  "Completion_Interrupt_c38",
      desc: "Rapresent the interrupt the platform should raise when it finishes to execute the received command",
      swaccess: "rw",
      hwaccess: "hro",
      fields: [
        { bits: "31:1",
          name: "Preserve_Mask",
          desc: "These bits must be constant to 0, not used with just one platform and one agent"
        },
        { bits: "0",
          name: "intr",
          desc: "Interrupt bit"
        }
      ],
    },
    { name: "Reserved_1_c39",
      desc: "Reserved, must be 0",
      swaccess: "rw",
      hwaccess: "none",
      fields: [
        { bits: "31:0" }
      ],
    },
    { name: "Channel_Status_c39",
      desc: "Indicates which entity has access to the Shared Memory",
      swaccess: "rw",
      hwaccess: "none",
      fields: [
        { bits: "31:2" },
        { bits: "1",
          name: "channel_error",
          desc: "Must be 0 in absence of errors"
        },
        { bits: "0",
          name: "channel_free",
          desc: "If 1 the agent own the channel, if 0 the platform own the channel"
        }
      ],
    },
    { name: "Reserved_2_c39",
      desc: "Reserved, implementation defined (32 bits over 64)",
      swaccess: "rw",
      hwaccess: "none",
      fields: [
        { bits: "31:0" }
      ],
    },
    { name: "Reserved_3_c39",
      desc: "Reserved, implementation defined (32 bits over 64)",
      swaccess: "none",
      hwaccess: "none",
      fields: [
        { bits: "31:0" }
      ],
    },
    { name: "Channel_Flags_c39",
      desc: "Defines wheter interrupts or polling is used for communication",
      swaccess: "rw",
      hwaccess: "none",
      fields: [
        { bits: "31:1" },
        { bits: "0",
          name: "intr_enable",
          desc: "If 1 interruts are used, if 0 polling is used"
        }
      ],
    },
    { name: "Length_c39",
      desc: "Lenght of payload + header",
      swaccess: "rw",
      hwaccess: "none",
      fields: [
        { bits: "31:0" }
      ],
    },
    { name: "Message_Header_c39",
      desc: "Defines which commanad the message contains",
      swaccess: "rw",
      hwaccess: "none",
      fields: [
        { bits: "31:28" },
        { bits: "27:18",
          name: "Token",
          desc: "must be same for the msg responses associated to a msg whith the same header"
        },
        { bits: "17:10",
          name: "Protocol_Id",
          desc: "Identifies to which protocol the command belongs to"
        },
        { bits: "9:8",
          name: "Message_Type",
          desc: "can be 0,1,2,3 depending on the kind of msg to be sent"
        },
        { bits: "7:0",
          name: "Message_Id",
          desc: "unique identifier for each command availabe in the protocol pointed by protocol_id"
        }
      ],
    },
    { name: "Message_Payload_1_c39",
      desc: "memory region dedicated to the parameters of the commands and their returns",
      swaccess: "rw",
      hwaccess: "none",
      fields: [
        { bits: "31:0" }
      ],
    },
    { name: "Doorbell_c39",
      desc: "Rapresents the interrupt to be raised towards the platform",
      swaccess: "rw",
      hwaccess: "hro",
      fields: [
        { bits: "31:1",
          name: "Preserve_Mask",
          desc: "These bits must be constant to 0, not used with just one platform and one agent"
        },
        { bits: "0",
          name: "intr",
          desc: "Interrupt bit"
        }
      ],
    },
    { name:  "Completion_Interrupt_c39",
      desc: "Rapresent the interrupt the platform should raise when it finishes to execute the received command",
      swaccess: "rw",
      hwaccess: "hro",
      fields: [
        { bits: "31:1",
          name: "Preserve_Mask",
          desc: "These bits must be constant to 0, not used with just one platform and one agent"
        },
        { bits: "0",
          name: "intr",
          desc: "Interrupt bit"
        }
      ],
    },
    { name: "Reserved_1_c40",
      desc: "Reserved, must be 0",
      swaccess: "rw",
      hwaccess: "none",
      fields: [
        { bits: "31:0" }
      ],
    },
    { name: "Channel_Status_c40",
      desc: "Indicates which entity has access to the Shared Memory",
      swaccess: "rw",
      hwaccess: "none",
      fields: [
        { bits: "31:2" },
        { bits: "1",
          name: "channel_error",
          desc: "Must be 0 in absence of errors"
        },
        { bits: "0",
          name: "channel_free",
          desc: "If 1 the agent own the channel, if 0 the platform own the channel"
        }
      ],
    },
    { name: "Reserved_2_c40",
      desc: "Reserved, implementation defined (32 bits over 64)",
      swaccess: "rw",
      hwaccess: "none",
      fields: [
        { bits: "31:0" }
      ],
    },
    { name: "Reserved_3_c40",
      desc: "Reserved, implementation defined (32 bits over 64)",
      swaccess: "none",
      hwaccess: "none",
      fields: [
        { bits: "31:0" }
      ],
    },
    { name: "Channel_Flags_c40",
      desc: "Defines wheter interrupts or polling is used for communication",
      swaccess: "rw",
      hwaccess: "none",
      fields: [
        { bits: "31:1" },
        { bits: "0",
          name: "intr_enable",
          desc: "If 1 interruts are used, if 0 polling is used"
        }
      ],
    },
    { name: "Length_c40",
      desc: "Lenght of payload + header",
      swaccess: "rw",
      hwaccess: "none",
      fields: [
        { bits: "31:0" }
      ],
    },
    { name: "Message_Header_c40",
      desc: "Defines which commanad the message contains",
      swaccess: "rw",
      hwaccess: "none",
      fields: [
        { bits: "31:28" },
        { bits: "27:18",
          name: "Token",
          desc: "must be same for the msg responses associated to a msg whith the same header"
        },
        { bits: "17:10",
          name: "Protocol_Id",
          desc: "Identifies to which protocol the command belongs to"
        },
        { bits: "9:8",
          name: "Message_Type",
          desc: "can be 0,1,2,3 depending on the kind of msg to be sent"
        },
        { bits: "7:0",
          name: "Message_Id",
          desc: "unique identifier for each command availabe in the protocol pointed by protocol_id"
        }
      ],
    },
    { name: "Message_Payload_1_c40",
      desc: "memory region dedicated to the parameters of the commands and their returns",
      swaccess: "rw",
      hwaccess: "none",
      fields: [
        { bits: "31:0" }
      ],
    },
    { name: "Doorbell_c40",
      desc: "Rapresents the interrupt to be raised towards the platform",
      swaccess: "rw",
      hwaccess: "hro",
      fields: [
        { bits: "31:1",
          name: "Preserve_Mask",
          desc: "These bits must be constant to 0, not used with just one platform and one agent"
        },
        { bits: "0",
          name: "intr",
          desc: "Interrupt bit"
        }
      ],
    },
    { name:  "Completion_Interrupt_c40",
      desc: "Rapresent the interrupt the platform should raise when it finishes to execute the received command",
      swaccess: "rw",
      hwaccess: "hro",
      fields: [
        { bits: "31:1",
          name: "Preserve_Mask",
          desc: "These bits must be constant to 0, not used with just one platform and one agent"
        },
        { bits: "0",
          name: "intr",
          desc: "Interrupt bit"
        }
      ],
    },
    { name: "Reserved_1_c41",
      desc: "Reserved, must be 0",
      swaccess: "rw",
      hwaccess: "none",
      fields: [
        { bits: "31:0" }
      ],
    },
    { name: "Channel_Status_c41",
      desc: "Indicates which entity has access to the Shared Memory",
      swaccess: "rw",
      hwaccess: "none",
      fields: [
        { bits: "31:2" },
        { bits: "1",
          name: "channel_error",
          desc: "Must be 0 in absence of errors"
        },
        { bits: "0",
          name: "channel_free",
          desc: "If 1 the agent own the channel, if 0 the platform own the channel"
        }
      ],
    },
    { name: "Reserved_2_c41",
      desc: "Reserved, implementation defined (32 bits over 64)",
      swaccess: "rw",
      hwaccess: "none",
      fields: [
        { bits: "31:0" }
      ],
    },
    { name: "Reserved_3_c41",
      desc: "Reserved, implementation defined (32 bits over 64)",
      swaccess: "none",
      hwaccess: "none",
      fields: [
        { bits: "31:0" }
      ],
    },
    { name: "Channel_Flags_c41",
      desc: "Defines wheter interrupts or polling is used for communication",
      swaccess: "rw",
      hwaccess: "none",
      fields: [
        { bits: "31:1" },
        { bits: "0",
          name: "intr_enable",
          desc: "If 1 interruts are used, if 0 polling is used"
        }
      ],
    },
    { name: "Length_c41",
      desc: "Lenght of payload + header",
      swaccess: "rw",
      hwaccess: "none",
      fields: [
        { bits: "31:0" }
      ],
    },
    { name: "Message_Header_c41",
      desc: "Defines which commanad the message contains",
      swaccess: "rw",
      hwaccess: "none",
      fields: [
        { bits: "31:28" },
        { bits: "27:18",
          name: "Token",
          desc: "must be same for the msg responses associated to a msg whith the same header"
        },
        { bits: "17:10",
          name: "Protocol_Id",
          desc: "Identifies to which protocol the command belongs to"
        },
        { bits: "9:8",
          name: "Message_Type",
          desc: "can be 0,1,2,3 depending on the kind of msg to be sent"
        },
        { bits: "7:0",
          name: "Message_Id",
          desc: "unique identifier for each command availabe in the protocol pointed by protocol_id"
        }
      ],
    },
    { name: "Message_Payload_1_c41",
      desc: "memory region dedicated to the parameters of the commands and their returns",
      swaccess: "rw",
      hwaccess: "none",
      fields: [
        { bits: "31:0" }
      ],
    },
    { name: "Doorbell_c41",
      desc: "Rapresents the interrupt to be raised towards the platform",
      swaccess: "rw",
      hwaccess: "hro",
      fields: [
        { bits: "31:1",
          name: "Preserve_Mask",
          desc: "These bits must be constant to 0, not used with just one platform and one agent"
        },
        { bits: "0",
          name: "intr",
          desc: "Interrupt bit"
        }
      ],
    },
    { name:  "Completion_Interrupt_c41",
      desc: "Rapresent the interrupt the platform should raise when it finishes to execute the received command",
      swaccess: "rw",
      hwaccess: "hro",
      fields: [
        { bits: "31:1",
          name: "Preserve_Mask",
          desc: "These bits must be constant to 0, not used with just one platform and one agent"
        },
        { bits: "0",
          name: "intr",
          desc: "Interrupt bit"
        }
      ],
    },
    { name: "Reserved_1_c42",
      desc: "Reserved, must be 0",
      swaccess: "rw",
      hwaccess: "none",
      fields: [
        { bits: "31:0" }
      ],
    },
    { name: "Channel_Status_c42",
      desc: "Indicates which entity has access to the Shared Memory",
      swaccess: "rw",
      hwaccess: "none",
      fields: [
        { bits: "31:2" },
        { bits: "1",
          name: "channel_error",
          desc: "Must be 0 in absence of errors"
        },
        { bits: "0",
          name: "channel_free",
          desc: "If 1 the agent own the channel, if 0 the platform own the channel"
        }
      ],
    },
    { name: "Reserved_2_c42",
      desc: "Reserved, implementation defined (32 bits over 64)",
      swaccess: "rw",
      hwaccess: "none",
      fields: [
        { bits: "31:0" }
      ],
    },
    { name: "Reserved_3_c42",
      desc: "Reserved, implementation defined (32 bits over 64)",
      swaccess: "none",
      hwaccess: "none",
      fields: [
        { bits: "31:0" }
      ],
    },
    { name: "Channel_Flags_c42",
      desc: "Defines wheter interrupts or polling is used for communication",
      swaccess: "rw",
      hwaccess: "none",
      fields: [
        { bits: "31:1" },
        { bits: "0",
          name: "intr_enable",
          desc: "If 1 interruts are used, if 0 polling is used"
        }
      ],
    },
    { name: "Length_c42",
      desc: "Lenght of payload + header",
      swaccess: "rw",
      hwaccess: "none",
      fields: [
        { bits: "31:0" }
      ],
    },
    { name: "Message_Header_c42",
      desc: "Defines which commanad the message contains",
      swaccess: "rw",
      hwaccess: "none",
      fields: [
        { bits: "31:28" },
        { bits: "27:18",
          name: "Token",
          desc: "must be same for the msg responses associated to a msg whith the same header"
        },
        { bits: "17:10",
          name: "Protocol_Id",
          desc: "Identifies to which protocol the command belongs to"
        },
        { bits: "9:8",
          name: "Message_Type",
          desc: "can be 0,1,2,3 depending on the kind of msg to be sent"
        },
        { bits: "7:0",
          name: "Message_Id",
          desc: "unique identifier for each command availabe in the protocol pointed by protocol_id"
        }
      ],
    },
    { name: "Message_Payload_1_c42",
      desc: "memory region dedicated to the parameters of the commands and their returns",
      swaccess: "rw",
      hwaccess: "none",
      fields: [
        { bits: "31:0" }
      ],
    },
    { name: "Doorbell_c42",
      desc: "Rapresents the interrupt to be raised towards the platform",
      swaccess: "rw",
      hwaccess: "hro",
      fields: [
        { bits: "31:1",
          name: "Preserve_Mask",
          desc: "These bits must be constant to 0, not used with just one platform and one agent"
        },
        { bits: "0",
          name: "intr",
          desc: "Interrupt bit"
        }
      ],
    },
    { name:  "Completion_Interrupt_c42",
      desc: "Rapresent the interrupt the platform should raise when it finishes to execute the received command",
      swaccess: "rw",
      hwaccess: "hro",
      fields: [
        { bits: "31:1",
          name: "Preserve_Mask",
          desc: "These bits must be constant to 0, not used with just one platform and one agent"
        },
        { bits: "0",
          name: "intr",
          desc: "Interrupt bit"
        }
      ],
    },
    { name: "Reserved_1_c43",
      desc: "Reserved, must be 0",
      swaccess: "rw",
      hwaccess: "none",
      fields: [
        { bits: "31:0" }
      ],
    },
    { name: "Channel_Status_c43",
      desc: "Indicates which entity has access to the Shared Memory",
      swaccess: "rw",
      hwaccess: "none",
      fields: [
        { bits: "31:2" },
        { bits: "1",
          name: "channel_error",
          desc: "Must be 0 in absence of errors"
        },
        { bits: "0",
          name: "channel_free",
          desc: "If 1 the agent own the channel, if 0 the platform own the channel"
        }
      ],
    },
    { name: "Reserved_2_c43",
      desc: "Reserved, implementation defined (32 bits over 64)",
      swaccess: "rw",
      hwaccess: "none",
      fields: [
        { bits: "31:0" }
      ],
    },
    { name: "Reserved_3_c43",
      desc: "Reserved, implementation defined (32 bits over 64)",
      swaccess: "none",
      hwaccess: "none",
      fields: [
        { bits: "31:0" }
      ],
    },
    { name: "Channel_Flags_c43",
      desc: "Defines wheter interrupts or polling is used for communication",
      swaccess: "rw",
      hwaccess: "none",
      fields: [
        { bits: "31:1" },
        { bits: "0",
          name: "intr_enable",
          desc: "If 1 interruts are used, if 0 polling is used"
        }
      ],
    },
    { name: "Length_c43",
      desc: "Lenght of payload + header",
      swaccess: "rw",
      hwaccess: "none",
      fields: [
        { bits: "31:0" }
      ],
    },
    { name: "Message_Header_c43",
      desc: "Defines which commanad the message contains",
      swaccess: "rw",
      hwaccess: "none",
      fields: [
        { bits: "31:28" },
        { bits: "27:18",
          name: "Token",
          desc: "must be same for the msg responses associated to a msg whith the same header"
        },
        { bits: "17:10",
          name: "Protocol_Id",
          desc: "Identifies to which protocol the command belongs to"
        },
        { bits: "9:8",
          name: "Message_Type",
          desc: "can be 0,1,2,3 depending on the kind of msg to be sent"
        },
        { bits: "7:0",
          name: "Message_Id",
          desc: "unique identifier for each command availabe in the protocol pointed by protocol_id"
        }
      ],
    },
    { name: "Message_Payload_1_c43",
      desc: "memory region dedicated to the parameters of the commands and their returns",
      swaccess: "rw",
      hwaccess: "none",
      fields: [
        { bits: "31:0" }
      ],
    },
    { name: "Doorbell_c43",
      desc: "Rapresents the interrupt to be raised towards the platform",
      swaccess: "rw",
      hwaccess: "hro",
      fields: [
        { bits: "31:1",
          name: "Preserve_Mask",
          desc: "These bits must be constant to 0, not used with just one platform and one agent"
        },
        { bits: "0",
          name: "intr",
          desc: "Interrupt bit"
        }
      ],
    },
    { name:  "Completion_Interrupt_c43",
      desc: "Rapresent the interrupt the platform should raise when it finishes to execute the received command",
      swaccess: "rw",
      hwaccess: "hro",
      fields: [
        { bits: "31:1",
          name: "Preserve_Mask",
          desc: "These bits must be constant to 0, not used with just one platform and one agent"
        },
        { bits: "0",
          name: "intr",
          desc: "Interrupt bit"
        }
      ],
    },
    { name: "Reserved_1_c44",
      desc: "Reserved, must be 0",
      swaccess: "rw",
      hwaccess: "none",
      fields: [
        { bits: "31:0" }
      ],
    },
    { name: "Channel_Status_c44",
      desc: "Indicates which entity has access to the Shared Memory",
      swaccess: "rw",
      hwaccess: "none",
      fields: [
        { bits: "31:2" },
        { bits: "1",
          name: "channel_error",
          desc: "Must be 0 in absence of errors"
        },
        { bits: "0",
          name: "channel_free",
          desc: "If 1 the agent own the channel, if 0 the platform own the channel"
        }
      ],
    },
    { name: "Reserved_2_c44",
      desc: "Reserved, implementation defined (32 bits over 64)",
      swaccess: "rw",
      hwaccess: "none",
      fields: [
        { bits: "31:0" }
      ],
    },
    { name: "Reserved_3_c44",
      desc: "Reserved, implementation defined (32 bits over 64)",
      swaccess: "none",
      hwaccess: "none",
      fields: [
        { bits: "31:0" }
      ],
    },
    { name: "Channel_Flags_c44",
      desc: "Defines wheter interrupts or polling is used for communication",
      swaccess: "rw",
      hwaccess: "none",
      fields: [
        { bits: "31:1" },
        { bits: "0",
          name: "intr_enable",
          desc: "If 1 interruts are used, if 0 polling is used"
        }
      ],
    },
    { name: "Length_c44",
      desc: "Lenght of payload + header",
      swaccess: "rw",
      hwaccess: "none",
      fields: [
        { bits: "31:0" }
      ],
    },
    { name: "Message_Header_c44",
      desc: "Defines which commanad the message contains",
      swaccess: "rw",
      hwaccess: "none",
      fields: [
        { bits: "31:28" },
        { bits: "27:18",
          name: "Token",
          desc: "must be same for the msg responses associated to a msg whith the same header"
        },
        { bits: "17:10",
          name: "Protocol_Id",
          desc: "Identifies to which protocol the command belongs to"
        },
        { bits: "9:8",
          name: "Message_Type",
          desc: "can be 0,1,2,3 depending on the kind of msg to be sent"
        },
        { bits: "7:0",
          name: "Message_Id",
          desc: "unique identifier for each command availabe in the protocol pointed by protocol_id"
        }
      ],
    },
    { name: "Message_Payload_1_c44",
      desc: "memory region dedicated to the parameters of the commands and their returns",
      swaccess: "rw",
      hwaccess: "none",
      fields: [
        { bits: "31:0" }
      ],
    },
    { name: "Doorbell_c44",
      desc: "Rapresents the interrupt to be raised towards the platform",
      swaccess: "rw",
      hwaccess: "hro",
      fields: [
        { bits: "31:1",
          name: "Preserve_Mask",
          desc: "These bits must be constant to 0, not used with just one platform and one agent"
        },
        { bits: "0",
          name: "intr",
          desc: "Interrupt bit"
        }
      ],
    },
    { name:  "Completion_Interrupt_c44",
      desc: "Rapresent the interrupt the platform should raise when it finishes to execute the received command",
      swaccess: "rw",
      hwaccess: "hro",
      fields: [
        { bits: "31:1",
          name: "Preserve_Mask",
          desc: "These bits must be constant to 0, not used with just one platform and one agent"
        },
        { bits: "0",
          name: "intr",
          desc: "Interrupt bit"
        }
      ],
    },
    { name: "Reserved_1_c45",
      desc: "Reserved, must be 0",
      swaccess: "rw",
      hwaccess: "none",
      fields: [
        { bits: "31:0" }
      ],
    },
    { name: "Channel_Status_c45",
      desc: "Indicates which entity has access to the Shared Memory",
      swaccess: "rw",
      hwaccess: "none",
      fields: [
        { bits: "31:2" },
        { bits: "1",
          name: "channel_error",
          desc: "Must be 0 in absence of errors"
        },
        { bits: "0",
          name: "channel_free",
          desc: "If 1 the agent own the channel, if 0 the platform own the channel"
        }
      ],
    },
    { name: "Reserved_2_c45",
      desc: "Reserved, implementation defined (32 bits over 64)",
      swaccess: "rw",
      hwaccess: "none",
      fields: [
        { bits: "31:0" }
      ],
    },
    { name: "Reserved_3_c45",
      desc: "Reserved, implementation defined (32 bits over 64)",
      swaccess: "none",
      hwaccess: "none",
      fields: [
        { bits: "31:0" }
      ],
    },
    { name: "Channel_Flags_c45",
      desc: "Defines wheter interrupts or polling is used for communication",
      swaccess: "rw",
      hwaccess: "none",
      fields: [
        { bits: "31:1" },
        { bits: "0",
          name: "intr_enable",
          desc: "If 1 interruts are used, if 0 polling is used"
        }
      ],
    },
    { name: "Length_c45",
      desc: "Lenght of payload + header",
      swaccess: "rw",
      hwaccess: "none",
      fields: [
        { bits: "31:0" }
      ],
    },
    { name: "Message_Header_c45",
      desc: "Defines which commanad the message contains",
      swaccess: "rw",
      hwaccess: "none",
      fields: [
        { bits: "31:28" },
        { bits: "27:18",
          name: "Token",
          desc: "must be same for the msg responses associated to a msg whith the same header"
        },
        { bits: "17:10",
          name: "Protocol_Id",
          desc: "Identifies to which protocol the command belongs to"
        },
        { bits: "9:8",
          name: "Message_Type",
          desc: "can be 0,1,2,3 depending on the kind of msg to be sent"
        },
        { bits: "7:0",
          name: "Message_Id",
          desc: "unique identifier for each command availabe in the protocol pointed by protocol_id"
        }
      ],
    },
    { name: "Message_Payload_1_c45",
      desc: "memory region dedicated to the parameters of the commands and their returns",
      swaccess: "rw",
      hwaccess: "none",
      fields: [
        { bits: "31:0" }
      ],
    },
    { name: "Doorbell_c45",
      desc: "Rapresents the interrupt to be raised towards the platform",
      swaccess: "rw",
      hwaccess: "hro",
      fields: [
        { bits: "31:1",
          name: "Preserve_Mask",
          desc: "These bits must be constant to 0, not used with just one platform and one agent"
        },
        { bits: "0",
          name: "intr",
          desc: "Interrupt bit"
        }
      ],
    },
    { name:  "Completion_Interrupt_c45",
      desc: "Rapresent the interrupt the platform should raise when it finishes to execute the received command",
      swaccess: "rw",
      hwaccess: "hro",
      fields: [
        { bits: "31:1",
          name: "Preserve_Mask",
          desc: "These bits must be constant to 0, not used with just one platform and one agent"
        },
        { bits: "0",
          name: "intr",
          desc: "Interrupt bit"
        }
      ],
    },
    { name: "Reserved_1_c46",
      desc: "Reserved, must be 0",
      swaccess: "rw",
      hwaccess: "none",
      fields: [
        { bits: "31:0" }
      ],
    },
    { name: "Channel_Status_c46",
      desc: "Indicates which entity has access to the Shared Memory",
      swaccess: "rw",
      hwaccess: "none",
      fields: [
        { bits: "31:2" },
        { bits: "1",
          name: "channel_error",
          desc: "Must be 0 in absence of errors"
        },
        { bits: "0",
          name: "channel_free",
          desc: "If 1 the agent own the channel, if 0 the platform own the channel"
        }
      ],
    },
    { name: "Reserved_2_c46",
      desc: "Reserved, implementation defined (32 bits over 64)",
      swaccess: "rw",
      hwaccess: "none",
      fields: [
        { bits: "31:0" }
      ],
    },
    { name: "Reserved_3_c46",
      desc: "Reserved, implementation defined (32 bits over 64)",
      swaccess: "none",
      hwaccess: "none",
      fields: [
        { bits: "31:0" }
      ],
    },
    { name: "Channel_Flags_c46",
      desc: "Defines wheter interrupts or polling is used for communication",
      swaccess: "rw",
      hwaccess: "none",
      fields: [
        { bits: "31:1" },
        { bits: "0",
          name: "intr_enable",
          desc: "If 1 interruts are used, if 0 polling is used"
        }
      ],
    },
    { name: "Length_c46",
      desc: "Lenght of payload + header",
      swaccess: "rw",
      hwaccess: "none",
      fields: [
        { bits: "31:0" }
      ],
    },
    { name: "Message_Header_c46",
      desc: "Defines which commanad the message contains",
      swaccess: "rw",
      hwaccess: "none",
      fields: [
        { bits: "31:28" },
        { bits: "27:18",
          name: "Token",
          desc: "must be same for the msg responses associated to a msg whith the same header"
        },
        { bits: "17:10",
          name: "Protocol_Id",
          desc: "Identifies to which protocol the command belongs to"
        },
        { bits: "9:8",
          name: "Message_Type",
          desc: "can be 0,1,2,3 depending on the kind of msg to be sent"
        },
        { bits: "7:0",
          name: "Message_Id",
          desc: "unique identifier for each command availabe in the protocol pointed by protocol_id"
        }
      ],
    },
    { name: "Message_Payload_1_c46",
      desc: "memory region dedicated to the parameters of the commands and their returns",
      swaccess: "rw",
      hwaccess: "none",
      fields: [
        { bits: "31:0" }
      ],
    },
    { name: "Doorbell_c46",
      desc: "Rapresents the interrupt to be raised towards the platform",
      swaccess: "rw",
      hwaccess: "hro",
      fields: [
        { bits: "31:1",
          name: "Preserve_Mask",
          desc: "These bits must be constant to 0, not used with just one platform and one agent"
        },
        { bits: "0",
          name: "intr",
          desc: "Interrupt bit"
        }
      ],
    },
    { name:  "Completion_Interrupt_c46",
      desc: "Rapresent the interrupt the platform should raise when it finishes to execute the received command",
      swaccess: "rw",
      hwaccess: "hro",
      fields: [
        { bits: "31:1",
          name: "Preserve_Mask",
          desc: "These bits must be constant to 0, not used with just one platform and one agent"
        },
        { bits: "0",
          name: "intr",
          desc: "Interrupt bit"
        }
      ],
    },
    { name: "Reserved_1_c47",
      desc: "Reserved, must be 0",
      swaccess: "rw",
      hwaccess: "none",
      fields: [
        { bits: "31:0" }
      ],
    },
    { name: "Channel_Status_c47",
      desc: "Indicates which entity has access to the Shared Memory",
      swaccess: "rw",
      hwaccess: "none",
      fields: [
        { bits: "31:2" },
        { bits: "1",
          name: "channel_error",
          desc: "Must be 0 in absence of errors"
        },
        { bits: "0",
          name: "channel_free",
          desc: "If 1 the agent own the channel, if 0 the platform own the channel"
        }
      ],
    },
    { name: "Reserved_2_c47",
      desc: "Reserved, implementation defined (32 bits over 64)",
      swaccess: "rw",
      hwaccess: "none",
      fields: [
        { bits: "31:0" }
      ],
    },
    { name: "Reserved_3_c47",
      desc: "Reserved, implementation defined (32 bits over 64)",
      swaccess: "none",
      hwaccess: "none",
      fields: [
        { bits: "31:0" }
      ],
    },
    { name: "Channel_Flags_c47",
      desc: "Defines wheter interrupts or polling is used for communication",
      swaccess: "rw",
      hwaccess: "none",
      fields: [
        { bits: "31:1" },
        { bits: "0",
          name: "intr_enable",
          desc: "If 1 interruts are used, if 0 polling is used"
        }
      ],
    },
    { name: "Length_c47",
      desc: "Lenght of payload + header",
      swaccess: "rw",
      hwaccess: "none",
      fields: [
        { bits: "31:0" }
      ],
    },
    { name: "Message_Header_c47",
      desc: "Defines which commanad the message contains",
      swaccess: "rw",
      hwaccess: "none",
      fields: [
        { bits: "31:28" },
        { bits: "27:18",
          name: "Token",
          desc: "must be same for the msg responses associated to a msg whith the same header"
        },
        { bits: "17:10",
          name: "Protocol_Id",
          desc: "Identifies to which protocol the command belongs to"
        },
        { bits: "9:8",
          name: "Message_Type",
          desc: "can be 0,1,2,3 depending on the kind of msg to be sent"
        },
        { bits: "7:0",
          name: "Message_Id",
          desc: "unique identifier for each command availabe in the protocol pointed by protocol_id"
        }
      ],
    },
    { name: "Message_Payload_1_c47",
      desc: "memory region dedicated to the parameters of the commands and their returns",
      swaccess: "rw",
      hwaccess: "none",
      fields: [
        { bits: "31:0" }
      ],
    },
    { name: "Doorbell_c47",
      desc: "Rapresents the interrupt to be raised towards the platform",
      swaccess: "rw",
      hwaccess: "hro",
      fields: [
        { bits: "31:1",
          name: "Preserve_Mask",
          desc: "These bits must be constant to 0, not used with just one platform and one agent"
        },
        { bits: "0",
          name: "intr",
          desc: "Interrupt bit"
        }
      ],
    },
    { name:  "Completion_Interrupt_c47",
      desc: "Rapresent the interrupt the platform should raise when it finishes to execute the received command",
      swaccess: "rw",
      hwaccess: "hro",
      fields: [
        { bits: "31:1",
          name: "Preserve_Mask",
          desc: "These bits must be constant to 0, not used with just one platform and one agent"
        },
        { bits: "0",
          name: "intr",
          desc: "Interrupt bit"
        }
      ],
    },
    { name: "Reserved_1_c48",
      desc: "Reserved, must be 0",
      swaccess: "rw",
      hwaccess: "none",
      fields: [
        { bits: "31:0" }
      ],
    },
    { name: "Channel_Status_c48",
      desc: "Indicates which entity has access to the Shared Memory",
      swaccess: "rw",
      hwaccess: "none",
      fields: [
        { bits: "31:2" },
        { bits: "1",
          name: "channel_error",
          desc: "Must be 0 in absence of errors"
        },
        { bits: "0",
          name: "channel_free",
          desc: "If 1 the agent own the channel, if 0 the platform own the channel"
        }
      ],
    },
    { name: "Reserved_2_c48",
      desc: "Reserved, implementation defined (32 bits over 64)",
      swaccess: "rw",
      hwaccess: "none",
      fields: [
        { bits: "31:0" }
      ],
    },
    { name: "Reserved_3_c48",
      desc: "Reserved, implementation defined (32 bits over 64)",
      swaccess: "none",
      hwaccess: "none",
      fields: [
        { bits: "31:0" }
      ],
    },
    { name: "Channel_Flags_c48",
      desc: "Defines wheter interrupts or polling is used for communication",
      swaccess: "rw",
      hwaccess: "none",
      fields: [
        { bits: "31:1" },
        { bits: "0",
          name: "intr_enable",
          desc: "If 1 interruts are used, if 0 polling is used"
        }
      ],
    },
    { name: "Length_c48",
      desc: "Lenght of payload + header",
      swaccess: "rw",
      hwaccess: "none",
      fields: [
        { bits: "31:0" }
      ],
    },
    { name: "Message_Header_c48",
      desc: "Defines which commanad the message contains",
      swaccess: "rw",
      hwaccess: "none",
      fields: [
        { bits: "31:28" },
        { bits: "27:18",
          name: "Token",
          desc: "must be same for the msg responses associated to a msg whith the same header"
        },
        { bits: "17:10",
          name: "Protocol_Id",
          desc: "Identifies to which protocol the command belongs to"
        },
        { bits: "9:8",
          name: "Message_Type",
          desc: "can be 0,1,2,3 depending on the kind of msg to be sent"
        },
        { bits: "7:0",
          name: "Message_Id",
          desc: "unique identifier for each command availabe in the protocol pointed by protocol_id"
        }
      ],
    },
    { name: "Message_Payload_1_c48",
      desc: "memory region dedicated to the parameters of the commands and their returns",
      swaccess: "rw",
      hwaccess: "none",
      fields: [
        { bits: "31:0" }
      ],
    },
    { name: "Doorbell_c48",
      desc: "Rapresents the interrupt to be raised towards the platform",
      swaccess: "rw",
      hwaccess: "hro",
      fields: [
        { bits: "31:1",
          name: "Preserve_Mask",
          desc: "These bits must be constant to 0, not used with just one platform and one agent"
        },
        { bits: "0",
          name: "intr",
          desc: "Interrupt bit"
        }
      ],
    },
    { name:  "Completion_Interrupt_c48",
      desc: "Rapresent the interrupt the platform should raise when it finishes to execute the received command",
      swaccess: "rw",
      hwaccess: "hro",
      fields: [
        { bits: "31:1",
          name: "Preserve_Mask",
          desc: "These bits must be constant to 0, not used with just one platform and one agent"
        },
        { bits: "0",
          name: "intr",
          desc: "Interrupt bit"
        }
      ],
    },
    { name: "Reserved_1_c49",
      desc: "Reserved, must be 0",
      swaccess: "rw",
      hwaccess: "none",
      fields: [
        { bits: "31:0" }
      ],
    },
    { name: "Channel_Status_c49",
      desc: "Indicates which entity has access to the Shared Memory",
      swaccess: "rw",
      hwaccess: "none",
      fields: [
        { bits: "31:2" },
        { bits: "1",
          name: "channel_error",
          desc: "Must be 0 in absence of errors"
        },
        { bits: "0",
          name: "channel_free",
          desc: "If 1 the agent own the channel, if 0 the platform own the channel"
        }
      ],
    },
    { name: "Reserved_2_c49",
      desc: "Reserved, implementation defined (32 bits over 64)",
      swaccess: "rw",
      hwaccess: "none",
      fields: [
        { bits: "31:0" }
      ],
    },
    { name: "Reserved_3_c49",
      desc: "Reserved, implementation defined (32 bits over 64)",
      swaccess: "none",
      hwaccess: "none",
      fields: [
        { bits: "31:0" }
      ],
    },
    { name: "Channel_Flags_c49",
      desc: "Defines wheter interrupts or polling is used for communication",
      swaccess: "rw",
      hwaccess: "none",
      fields: [
        { bits: "31:1" },
        { bits: "0",
          name: "intr_enable",
          desc: "If 1 interruts are used, if 0 polling is used"
        }
      ],
    },
    { name: "Length_c49",
      desc: "Lenght of payload + header",
      swaccess: "rw",
      hwaccess: "none",
      fields: [
        { bits: "31:0" }
      ],
    },
    { name: "Message_Header_c49",
      desc: "Defines which commanad the message contains",
      swaccess: "rw",
      hwaccess: "none",
      fields: [
        { bits: "31:28" },
        { bits: "27:18",
          name: "Token",
          desc: "must be same for the msg responses associated to a msg whith the same header"
        },
        { bits: "17:10",
          name: "Protocol_Id",
          desc: "Identifies to which protocol the command belongs to"
        },
        { bits: "9:8",
          name: "Message_Type",
          desc: "can be 0,1,2,3 depending on the kind of msg to be sent"
        },
        { bits: "7:0",
          name: "Message_Id",
          desc: "unique identifier for each command availabe in the protocol pointed by protocol_id"
        }
      ],
    },
    { name: "Message_Payload_1_c49",
      desc: "memory region dedicated to the parameters of the commands and their returns",
      swaccess: "rw",
      hwaccess: "none",
      fields: [
        { bits: "31:0" }
      ],
    },
    { name: "Doorbell_c49",
      desc: "Rapresents the interrupt to be raised towards the platform",
      swaccess: "rw",
      hwaccess: "hro",
      fields: [
        { bits: "31:1",
          name: "Preserve_Mask",
          desc: "These bits must be constant to 0, not used with just one platform and one agent"
        },
        { bits: "0",
          name: "intr",
          desc: "Interrupt bit"
        }
      ],
    },
    { name:  "Completion_Interrupt_c49",
      desc: "Rapresent the interrupt the platform should raise when it finishes to execute the received command",
      swaccess: "rw",
      hwaccess: "hro",
      fields: [
        { bits: "31:1",
          name: "Preserve_Mask",
          desc: "These bits must be constant to 0, not used with just one platform and one agent"
        },
        { bits: "0",
          name: "intr",
          desc: "Interrupt bit"
        }
      ],
    },
    { name: "Reserved_1_c50",
      desc: "Reserved, must be 0",
      swaccess: "rw",
      hwaccess: "none",
      fields: [
        { bits: "31:0" }
      ],
    },
    { name: "Channel_Status_c50",
      desc: "Indicates which entity has access to the Shared Memory",
      swaccess: "rw",
      hwaccess: "none",
      fields: [
        { bits: "31:2" },
        { bits: "1",
          name: "channel_error",
          desc: "Must be 0 in absence of errors"
        },
        { bits: "0",
          name: "channel_free",
          desc: "If 1 the agent own the channel, if 0 the platform own the channel"
        }
      ],
    },
    { name: "Reserved_2_c50",
      desc: "Reserved, implementation defined (32 bits over 64)",
      swaccess: "rw",
      hwaccess: "none",
      fields: [
        { bits: "31:0" }
      ],
    },
    { name: "Reserved_3_c50",
      desc: "Reserved, implementation defined (32 bits over 64)",
      swaccess: "none",
      hwaccess: "none",
      fields: [
        { bits: "31:0" }
      ],
    },
    { name: "Channel_Flags_c50",
      desc: "Defines wheter interrupts or polling is used for communication",
      swaccess: "rw",
      hwaccess: "none",
      fields: [
        { bits: "31:1" },
        { bits: "0",
          name: "intr_enable",
          desc: "If 1 interruts are used, if 0 polling is used"
        }
      ],
    },
    { name: "Length_c50",
      desc: "Lenght of payload + header",
      swaccess: "rw",
      hwaccess: "none",
      fields: [
        { bits: "31:0" }
      ],
    },
    { name: "Message_Header_c50",
      desc: "Defines which commanad the message contains",
      swaccess: "rw",
      hwaccess: "none",
      fields: [
        { bits: "31:28" },
        { bits: "27:18",
          name: "Token",
          desc: "must be same for the msg responses associated to a msg whith the same header"
        },
        { bits: "17:10",
          name: "Protocol_Id",
          desc: "Identifies to which protocol the command belongs to"
        },
        { bits: "9:8",
          name: "Message_Type",
          desc: "can be 0,1,2,3 depending on the kind of msg to be sent"
        },
        { bits: "7:0",
          name: "Message_Id",
          desc: "unique identifier for each command availabe in the protocol pointed by protocol_id"
        }
      ],
    },
    { name: "Message_Payload_1_c50",
      desc: "memory region dedicated to the parameters of the commands and their returns",
      swaccess: "rw",
      hwaccess: "none",
      fields: [
        { bits: "31:0" }
      ],
    },
    { name: "Doorbell_c50",
      desc: "Rapresents the interrupt to be raised towards the platform",
      swaccess: "rw",
      hwaccess: "hro",
      fields: [
        { bits: "31:1",
          name: "Preserve_Mask",
          desc: "These bits must be constant to 0, not used with just one platform and one agent"
        },
        { bits: "0",
          name: "intr",
          desc: "Interrupt bit"
        }
      ],
    },
    { name:  "Completion_Interrupt_c50",
      desc: "Rapresent the interrupt the platform should raise when it finishes to execute the received command",
      swaccess: "rw",
      hwaccess: "hro",
      fields: [
        { bits: "31:1",
          name: "Preserve_Mask",
          desc: "These bits must be constant to 0, not used with just one platform and one agent"
        },
        { bits: "0",
          name: "intr",
          desc: "Interrupt bit"
        }
      ],
    },
    { name: "Reserved_1_c51",
      desc: "Reserved, must be 0",
      swaccess: "rw",
      hwaccess: "none",
      fields: [
        { bits: "31:0" }
      ],
    },
    { name: "Channel_Status_c51",
      desc: "Indicates which entity has access to the Shared Memory",
      swaccess: "rw",
      hwaccess: "none",
      fields: [
        { bits: "31:2" },
        { bits: "1",
          name: "channel_error",
          desc: "Must be 0 in absence of errors"
        },
        { bits: "0",
          name: "channel_free",
          desc: "If 1 the agent own the channel, if 0 the platform own the channel"
        }
      ],
    },
    { name: "Reserved_2_c51",
      desc: "Reserved, implementation defined (32 bits over 64)",
      swaccess: "rw",
      hwaccess: "none",
      fields: [
        { bits: "31:0" }
      ],
    },
    { name: "Reserved_3_c51",
      desc: "Reserved, implementation defined (32 bits over 64)",
      swaccess: "none",
      hwaccess: "none",
      fields: [
        { bits: "31:0" }
      ],
    },
    { name: "Channel_Flags_c51",
      desc: "Defines wheter interrupts or polling is used for communication",
      swaccess: "rw",
      hwaccess: "none",
      fields: [
        { bits: "31:1" },
        { bits: "0",
          name: "intr_enable",
          desc: "If 1 interruts are used, if 0 polling is used"
        }
      ],
    },
    { name: "Length_c51",
      desc: "Lenght of payload + header",
      swaccess: "rw",
      hwaccess: "none",
      fields: [
        { bits: "31:0" }
      ],
    },
    { name: "Message_Header_c51",
      desc: "Defines which commanad the message contains",
      swaccess: "rw",
      hwaccess: "none",
      fields: [
        { bits: "31:28" },
        { bits: "27:18",
          name: "Token",
          desc: "must be same for the msg responses associated to a msg whith the same header"
        },
        { bits: "17:10",
          name: "Protocol_Id",
          desc: "Identifies to which protocol the command belongs to"
        },
        { bits: "9:8",
          name: "Message_Type",
          desc: "can be 0,1,2,3 depending on the kind of msg to be sent"
        },
        { bits: "7:0",
          name: "Message_Id",
          desc: "unique identifier for each command availabe in the protocol pointed by protocol_id"
        }
      ],
    },
    { name: "Message_Payload_1_c51",
      desc: "memory region dedicated to the parameters of the commands and their returns",
      swaccess: "rw",
      hwaccess: "none",
      fields: [
        { bits: "31:0" }
      ],
    },
    { name: "Doorbell_c51",
      desc: "Rapresents the interrupt to be raised towards the platform",
      swaccess: "rw",
      hwaccess: "hro",
      fields: [
        { bits: "31:1",
          name: "Preserve_Mask",
          desc: "These bits must be constant to 0, not used with just one platform and one agent"
        },
        { bits: "0",
          name: "intr",
          desc: "Interrupt bit"
        }
      ],
    },
    { name:  "Completion_Interrupt_c51",
      desc: "Rapresent the interrupt the platform should raise when it finishes to execute the received command",
      swaccess: "rw",
      hwaccess: "hro",
      fields: [
        { bits: "31:1",
          name: "Preserve_Mask",
          desc: "These bits must be constant to 0, not used with just one platform and one agent"
        },
        { bits: "0",
          name: "intr",
          desc: "Interrupt bit"
        }
      ],
    },
    { name: "Reserved_1_c52",
      desc: "Reserved, must be 0",
      swaccess: "rw",
      hwaccess: "none",
      fields: [
        { bits: "31:0" }
      ],
    },
    { name: "Channel_Status_c52",
      desc: "Indicates which entity has access to the Shared Memory",
      swaccess: "rw",
      hwaccess: "none",
      fields: [
        { bits: "31:2" },
        { bits: "1",
          name: "channel_error",
          desc: "Must be 0 in absence of errors"
        },
        { bits: "0",
          name: "channel_free",
          desc: "If 1 the agent own the channel, if 0 the platform own the channel"
        }
      ],
    },
    { name: "Reserved_2_c52",
      desc: "Reserved, implementation defined (32 bits over 64)",
      swaccess: "rw",
      hwaccess: "none",
      fields: [
        { bits: "31:0" }
      ],
    },
    { name: "Reserved_3_c52",
      desc: "Reserved, implementation defined (32 bits over 64)",
      swaccess: "none",
      hwaccess: "none",
      fields: [
        { bits: "31:0" }
      ],
    },
    { name: "Channel_Flags_c52",
      desc: "Defines wheter interrupts or polling is used for communication",
      swaccess: "rw",
      hwaccess: "none",
      fields: [
        { bits: "31:1" },
        { bits: "0",
          name: "intr_enable",
          desc: "If 1 interruts are used, if 0 polling is used"
        }
      ],
    },
    { name: "Length_c52",
      desc: "Lenght of payload + header",
      swaccess: "rw",
      hwaccess: "none",
      fields: [
        { bits: "31:0" }
      ],
    },
    { name: "Message_Header_c52",
      desc: "Defines which commanad the message contains",
      swaccess: "rw",
      hwaccess: "none",
      fields: [
        { bits: "31:28" },
        { bits: "27:18",
          name: "Token",
          desc: "must be same for the msg responses associated to a msg whith the same header"
        },
        { bits: "17:10",
          name: "Protocol_Id",
          desc: "Identifies to which protocol the command belongs to"
        },
        { bits: "9:8",
          name: "Message_Type",
          desc: "can be 0,1,2,3 depending on the kind of msg to be sent"
        },
        { bits: "7:0",
          name: "Message_Id",
          desc: "unique identifier for each command availabe in the protocol pointed by protocol_id"
        }
      ],
    },
    { name: "Message_Payload_1_c52",
      desc: "memory region dedicated to the parameters of the commands and their returns",
      swaccess: "rw",
      hwaccess: "none",
      fields: [
        { bits: "31:0" }
      ],
    },
    { name: "Doorbell_c52",
      desc: "Rapresents the interrupt to be raised towards the platform",
      swaccess: "rw",
      hwaccess: "hro",
      fields: [
        { bits: "31:1",
          name: "Preserve_Mask",
          desc: "These bits must be constant to 0, not used with just one platform and one agent"
        },
        { bits: "0",
          name: "intr",
          desc: "Interrupt bit"
        }
      ],
    },
    { name:  "Completion_Interrupt_c52",
      desc: "Rapresent the interrupt the platform should raise when it finishes to execute the received command",
      swaccess: "rw",
      hwaccess: "hro",
      fields: [
        { bits: "31:1",
          name: "Preserve_Mask",
          desc: "These bits must be constant to 0, not used with just one platform and one agent"
        },
        { bits: "0",
          name: "intr",
          desc: "Interrupt bit"
        }
      ],
    },
    { name: "Reserved_1_c53",
      desc: "Reserved, must be 0",
      swaccess: "rw",
      hwaccess: "none",
      fields: [
        { bits: "31:0" }
      ],
    },
    { name: "Channel_Status_c53",
      desc: "Indicates which entity has access to the Shared Memory",
      swaccess: "rw",
      hwaccess: "none",
      fields: [
        { bits: "31:2" },
        { bits: "1",
          name: "channel_error",
          desc: "Must be 0 in absence of errors"
        },
        { bits: "0",
          name: "channel_free",
          desc: "If 1 the agent own the channel, if 0 the platform own the channel"
        }
      ],
    },
    { name: "Reserved_2_c53",
      desc: "Reserved, implementation defined (32 bits over 64)",
      swaccess: "rw",
      hwaccess: "none",
      fields: [
        { bits: "31:0" }
      ],
    },
    { name: "Reserved_3_c53",
      desc: "Reserved, implementation defined (32 bits over 64)",
      swaccess: "none",
      hwaccess: "none",
      fields: [
        { bits: "31:0" }
      ],
    },
    { name: "Channel_Flags_c53",
      desc: "Defines wheter interrupts or polling is used for communication",
      swaccess: "rw",
      hwaccess: "none",
      fields: [
        { bits: "31:1" },
        { bits: "0",
          name: "intr_enable",
          desc: "If 1 interruts are used, if 0 polling is used"
        }
      ],
    },
    { name: "Length_c53",
      desc: "Lenght of payload + header",
      swaccess: "rw",
      hwaccess: "none",
      fields: [
        { bits: "31:0" }
      ],
    },
    { name: "Message_Header_c53",
      desc: "Defines which commanad the message contains",
      swaccess: "rw",
      hwaccess: "none",
      fields: [
        { bits: "31:28" },
        { bits: "27:18",
          name: "Token",
          desc: "must be same for the msg responses associated to a msg whith the same header"
        },
        { bits: "17:10",
          name: "Protocol_Id",
          desc: "Identifies to which protocol the command belongs to"
        },
        { bits: "9:8",
          name: "Message_Type",
          desc: "can be 0,1,2,3 depending on the kind of msg to be sent"
        },
        { bits: "7:0",
          name: "Message_Id",
          desc: "unique identifier for each command availabe in the protocol pointed by protocol_id"
        }
      ],
    },
    { name: "Message_Payload_1_c53",
      desc: "memory region dedicated to the parameters of the commands and their returns",
      swaccess: "rw",
      hwaccess: "none",
      fields: [
        { bits: "31:0" }
      ],
    },
    { name: "Doorbell_c53",
      desc: "Rapresents the interrupt to be raised towards the platform",
      swaccess: "rw",
      hwaccess: "hro",
      fields: [
        { bits: "31:1",
          name: "Preserve_Mask",
          desc: "These bits must be constant to 0, not used with just one platform and one agent"
        },
        { bits: "0",
          name: "intr",
          desc: "Interrupt bit"
        }
      ],
    },
    { name:  "Completion_Interrupt_c53",
      desc: "Rapresent the interrupt the platform should raise when it finishes to execute the received command",
      swaccess: "rw",
      hwaccess: "hro",
      fields: [
        { bits: "31:1",
          name: "Preserve_Mask",
          desc: "These bits must be constant to 0, not used with just one platform and one agent"
        },
        { bits: "0",
          name: "intr",
          desc: "Interrupt bit"
        }
      ],
    },
    { name: "Reserved_1_c54",
      desc: "Reserved, must be 0",
      swaccess: "rw",
      hwaccess: "none",
      fields: [
        { bits: "31:0" }
      ],
    },
    { name: "Channel_Status_c54",
      desc: "Indicates which entity has access to the Shared Memory",
      swaccess: "rw",
      hwaccess: "none",
      fields: [
        { bits: "31:2" },
        { bits: "1",
          name: "channel_error",
          desc: "Must be 0 in absence of errors"
        },
        { bits: "0",
          name: "channel_free",
          desc: "If 1 the agent own the channel, if 0 the platform own the channel"
        }
      ],
    },
    { name: "Reserved_2_c54",
      desc: "Reserved, implementation defined (32 bits over 64)",
      swaccess: "rw",
      hwaccess: "none",
      fields: [
        { bits: "31:0" }
      ],
    },
    { name: "Reserved_3_c54",
      desc: "Reserved, implementation defined (32 bits over 64)",
      swaccess: "none",
      hwaccess: "none",
      fields: [
        { bits: "31:0" }
      ],
    },
    { name: "Channel_Flags_c54",
      desc: "Defines wheter interrupts or polling is used for communication",
      swaccess: "rw",
      hwaccess: "none",
      fields: [
        { bits: "31:1" },
        { bits: "0",
          name: "intr_enable",
          desc: "If 1 interruts are used, if 0 polling is used"
        }
      ],
    },
    { name: "Length_c54",
      desc: "Lenght of payload + header",
      swaccess: "rw",
      hwaccess: "none",
      fields: [
        { bits: "31:0" }
      ],
    },
    { name: "Message_Header_c54",
      desc: "Defines which commanad the message contains",
      swaccess: "rw",
      hwaccess: "none",
      fields: [
        { bits: "31:28" },
        { bits: "27:18",
          name: "Token",
          desc: "must be same for the msg responses associated to a msg whith the same header"
        },
        { bits: "17:10",
          name: "Protocol_Id",
          desc: "Identifies to which protocol the command belongs to"
        },
        { bits: "9:8",
          name: "Message_Type",
          desc: "can be 0,1,2,3 depending on the kind of msg to be sent"
        },
        { bits: "7:0",
          name: "Message_Id",
          desc: "unique identifier for each command availabe in the protocol pointed by protocol_id"
        }
      ],
    },
    { name: "Message_Payload_1_c54",
      desc: "memory region dedicated to the parameters of the commands and their returns",
      swaccess: "rw",
      hwaccess: "none",
      fields: [
        { bits: "31:0" }
      ],
    },
    { name: "Doorbell_c54",
      desc: "Rapresents the interrupt to be raised towards the platform",
      swaccess: "rw",
      hwaccess: "hro",
      fields: [
        { bits: "31:1",
          name: "Preserve_Mask",
          desc: "These bits must be constant to 0, not used with just one platform and one agent"
        },
        { bits: "0",
          name: "intr",
          desc: "Interrupt bit"
        }
      ],
    },
    { name:  "Completion_Interrupt_c54",
      desc: "Rapresent the interrupt the platform should raise when it finishes to execute the received command",
      swaccess: "rw",
      hwaccess: "hro",
      fields: [
        { bits: "31:1",
          name: "Preserve_Mask",
          desc: "These bits must be constant to 0, not used with just one platform and one agent"
        },
        { bits: "0",
          name: "intr",
          desc: "Interrupt bit"
        }
      ],
    },
    { name: "Reserved_1_c55",
      desc: "Reserved, must be 0",
      swaccess: "rw",
      hwaccess: "none",
      fields: [
        { bits: "31:0" }
      ],
    },
    { name: "Channel_Status_c55",
      desc: "Indicates which entity has access to the Shared Memory",
      swaccess: "rw",
      hwaccess: "none",
      fields: [
        { bits: "31:2" },
        { bits: "1",
          name: "channel_error",
          desc: "Must be 0 in absence of errors"
        },
        { bits: "0",
          name: "channel_free",
          desc: "If 1 the agent own the channel, if 0 the platform own the channel"
        }
      ],
    },
    { name: "Reserved_2_c55",
      desc: "Reserved, implementation defined (32 bits over 64)",
      swaccess: "rw",
      hwaccess: "none",
      fields: [
        { bits: "31:0" }
      ],
    },
    { name: "Reserved_3_c55",
      desc: "Reserved, implementation defined (32 bits over 64)",
      swaccess: "none",
      hwaccess: "none",
      fields: [
        { bits: "31:0" }
      ],
    },
    { name: "Channel_Flags_c55",
      desc: "Defines wheter interrupts or polling is used for communication",
      swaccess: "rw",
      hwaccess: "none",
      fields: [
        { bits: "31:1" },
        { bits: "0",
          name: "intr_enable",
          desc: "If 1 interruts are used, if 0 polling is used"
        }
      ],
    },
    { name: "Length_c55",
      desc: "Lenght of payload + header",
      swaccess: "rw",
      hwaccess: "none",
      fields: [
        { bits: "31:0" }
      ],
    },
    { name: "Message_Header_c55",
      desc: "Defines which commanad the message contains",
      swaccess: "rw",
      hwaccess: "none",
      fields: [
        { bits: "31:28" },
        { bits: "27:18",
          name: "Token",
          desc: "must be same for the msg responses associated to a msg whith the same header"
        },
        { bits: "17:10",
          name: "Protocol_Id",
          desc: "Identifies to which protocol the command belongs to"
        },
        { bits: "9:8",
          name: "Message_Type",
          desc: "can be 0,1,2,3 depending on the kind of msg to be sent"
        },
        { bits: "7:0",
          name: "Message_Id",
          desc: "unique identifier for each command availabe in the protocol pointed by protocol_id"
        }
      ],
    },
    { name: "Message_Payload_1_c55",
      desc: "memory region dedicated to the parameters of the commands and their returns",
      swaccess: "rw",
      hwaccess: "none",
      fields: [
        { bits: "31:0" }
      ],
    },
    { name: "Doorbell_c55",
      desc: "Rapresents the interrupt to be raised towards the platform",
      swaccess: "rw",
      hwaccess: "hro",
      fields: [
        { bits: "31:1",
          name: "Preserve_Mask",
          desc: "These bits must be constant to 0, not used with just one platform and one agent"
        },
        { bits: "0",
          name: "intr",
          desc: "Interrupt bit"
        }
      ],
    },
    { name:  "Completion_Interrupt_c55",
      desc: "Rapresent the interrupt the platform should raise when it finishes to execute the received command",
      swaccess: "rw",
      hwaccess: "hro",
      fields: [
        { bits: "31:1",
          name: "Preserve_Mask",
          desc: "These bits must be constant to 0, not used with just one platform and one agent"
        },
        { bits: "0",
          name: "intr",
          desc: "Interrupt bit"
        }
      ],
    },
    { name: "Reserved_1_c56",
      desc: "Reserved, must be 0",
      swaccess: "rw",
      hwaccess: "none",
      fields: [
        { bits: "31:0" }
      ],
    },
    { name: "Channel_Status_c56",
      desc: "Indicates which entity has access to the Shared Memory",
      swaccess: "rw",
      hwaccess: "none",
      fields: [
        { bits: "31:2" },
        { bits: "1",
          name: "channel_error",
          desc: "Must be 0 in absence of errors"
        },
        { bits: "0",
          name: "channel_free",
          desc: "If 1 the agent own the channel, if 0 the platform own the channel"
        }
      ],
    },
    { name: "Reserved_2_c56",
      desc: "Reserved, implementation defined (32 bits over 64)",
      swaccess: "rw",
      hwaccess: "none",
      fields: [
        { bits: "31:0" }
      ],
    },
    { name: "Reserved_3_c56",
      desc: "Reserved, implementation defined (32 bits over 64)",
      swaccess: "none",
      hwaccess: "none",
      fields: [
        { bits: "31:0" }
      ],
    },
    { name: "Channel_Flags_c56",
      desc: "Defines wheter interrupts or polling is used for communication",
      swaccess: "rw",
      hwaccess: "none",
      fields: [
        { bits: "31:1" },
        { bits: "0",
          name: "intr_enable",
          desc: "If 1 interruts are used, if 0 polling is used"
        }
      ],
    },
    { name: "Length_c56",
      desc: "Lenght of payload + header",
      swaccess: "rw",
      hwaccess: "none",
      fields: [
        { bits: "31:0" }
      ],
    },
    { name: "Message_Header_c56",
      desc: "Defines which commanad the message contains",
      swaccess: "rw",
      hwaccess: "none",
      fields: [
        { bits: "31:28" },
        { bits: "27:18",
          name: "Token",
          desc: "must be same for the msg responses associated to a msg whith the same header"
        },
        { bits: "17:10",
          name: "Protocol_Id",
          desc: "Identifies to which protocol the command belongs to"
        },
        { bits: "9:8",
          name: "Message_Type",
          desc: "can be 0,1,2,3 depending on the kind of msg to be sent"
        },
        { bits: "7:0",
          name: "Message_Id",
          desc: "unique identifier for each command availabe in the protocol pointed by protocol_id"
        }
      ],
    },
    { name: "Message_Payload_1_c56",
      desc: "memory region dedicated to the parameters of the commands and their returns",
      swaccess: "rw",
      hwaccess: "none",
      fields: [
        { bits: "31:0" }
      ],
    },
    { name: "Doorbell_c56",
      desc: "Rapresents the interrupt to be raised towards the platform",
      swaccess: "rw",
      hwaccess: "hro",
      fields: [
        { bits: "31:1",
          name: "Preserve_Mask",
          desc: "These bits must be constant to 0, not used with just one platform and one agent"
        },
        { bits: "0",
          name: "intr",
          desc: "Interrupt bit"
        }
      ],
    },
    { name:  "Completion_Interrupt_c56",
      desc: "Rapresent the interrupt the platform should raise when it finishes to execute the received command",
      swaccess: "rw",
      hwaccess: "hro",
      fields: [
        { bits: "31:1",
          name: "Preserve_Mask",
          desc: "These bits must be constant to 0, not used with just one platform and one agent"
        },
        { bits: "0",
          name: "intr",
          desc: "Interrupt bit"
        }
      ],
    },
    { name: "Reserved_1_c57",
      desc: "Reserved, must be 0",
      swaccess: "rw",
      hwaccess: "none",
      fields: [
        { bits: "31:0" }
      ],
    },
    { name: "Channel_Status_c57",
      desc: "Indicates which entity has access to the Shared Memory",
      swaccess: "rw",
      hwaccess: "none",
      fields: [
        { bits: "31:2" },
        { bits: "1",
          name: "channel_error",
          desc: "Must be 0 in absence of errors"
        },
        { bits: "0",
          name: "channel_free",
          desc: "If 1 the agent own the channel, if 0 the platform own the channel"
        }
      ],
    },
    { name: "Reserved_2_c57",
      desc: "Reserved, implementation defined (32 bits over 64)",
      swaccess: "rw",
      hwaccess: "none",
      fields: [
        { bits: "31:0" }
      ],
    },
    { name: "Reserved_3_c57",
      desc: "Reserved, implementation defined (32 bits over 64)",
      swaccess: "none",
      hwaccess: "none",
      fields: [
        { bits: "31:0" }
      ],
    },
    { name: "Channel_Flags_c57",
      desc: "Defines wheter interrupts or polling is used for communication",
      swaccess: "rw",
      hwaccess: "none",
      fields: [
        { bits: "31:1" },
        { bits: "0",
          name: "intr_enable",
          desc: "If 1 interruts are used, if 0 polling is used"
        }
      ],
    },
    { name: "Length_c57",
      desc: "Lenght of payload + header",
      swaccess: "rw",
      hwaccess: "none",
      fields: [
        { bits: "31:0" }
      ],
    },
    { name: "Message_Header_c57",
      desc: "Defines which commanad the message contains",
      swaccess: "rw",
      hwaccess: "none",
      fields: [
        { bits: "31:28" },
        { bits: "27:18",
          name: "Token",
          desc: "must be same for the msg responses associated to a msg whith the same header"
        },
        { bits: "17:10",
          name: "Protocol_Id",
          desc: "Identifies to which protocol the command belongs to"
        },
        { bits: "9:8",
          name: "Message_Type",
          desc: "can be 0,1,2,3 depending on the kind of msg to be sent"
        },
        { bits: "7:0",
          name: "Message_Id",
          desc: "unique identifier for each command availabe in the protocol pointed by protocol_id"
        }
      ],
    },
    { name: "Message_Payload_1_c57",
      desc: "memory region dedicated to the parameters of the commands and their returns",
      swaccess: "rw",
      hwaccess: "none",
      fields: [
        { bits: "31:0" }
      ],
    },
    { name: "Doorbell_c57",
      desc: "Rapresents the interrupt to be raised towards the platform",
      swaccess: "rw",
      hwaccess: "hro",
      fields: [
        { bits: "31:1",
          name: "Preserve_Mask",
          desc: "These bits must be constant to 0, not used with just one platform and one agent"
        },
        { bits: "0",
          name: "intr",
          desc: "Interrupt bit"
        }
      ],
    },
    { name:  "Completion_Interrupt_c57",
      desc: "Rapresent the interrupt the platform should raise when it finishes to execute the received command",
      swaccess: "rw",
      hwaccess: "hro",
      fields: [
        { bits: "31:1",
          name: "Preserve_Mask",
          desc: "These bits must be constant to 0, not used with just one platform and one agent"
        },
        { bits: "0",
          name: "intr",
          desc: "Interrupt bit"
        }
      ],
    },
    { name: "Reserved_1_c58",
      desc: "Reserved, must be 0",
      swaccess: "rw",
      hwaccess: "none",
      fields: [
        { bits: "31:0" }
      ],
    },
    { name: "Channel_Status_c58",
      desc: "Indicates which entity has access to the Shared Memory",
      swaccess: "rw",
      hwaccess: "none",
      fields: [
        { bits: "31:2" },
        { bits: "1",
          name: "channel_error",
          desc: "Must be 0 in absence of errors"
        },
        { bits: "0",
          name: "channel_free",
          desc: "If 1 the agent own the channel, if 0 the platform own the channel"
        }
      ],
    },
    { name: "Reserved_2_c58",
      desc: "Reserved, implementation defined (32 bits over 64)",
      swaccess: "rw",
      hwaccess: "none",
      fields: [
        { bits: "31:0" }
      ],
    },
    { name: "Reserved_3_c58",
      desc: "Reserved, implementation defined (32 bits over 64)",
      swaccess: "none",
      hwaccess: "none",
      fields: [
        { bits: "31:0" }
      ],
    },
    { name: "Channel_Flags_c58",
      desc: "Defines wheter interrupts or polling is used for communication",
      swaccess: "rw",
      hwaccess: "none",
      fields: [
        { bits: "31:1" },
        { bits: "0",
          name: "intr_enable",
          desc: "If 1 interruts are used, if 0 polling is used"
        }
      ],
    },
    { name: "Length_c58",
      desc: "Lenght of payload + header",
      swaccess: "rw",
      hwaccess: "none",
      fields: [
        { bits: "31:0" }
      ],
    },
    { name: "Message_Header_c58",
      desc: "Defines which commanad the message contains",
      swaccess: "rw",
      hwaccess: "none",
      fields: [
        { bits: "31:28" },
        { bits: "27:18",
          name: "Token",
          desc: "must be same for the msg responses associated to a msg whith the same header"
        },
        { bits: "17:10",
          name: "Protocol_Id",
          desc: "Identifies to which protocol the command belongs to"
        },
        { bits: "9:8",
          name: "Message_Type",
          desc: "can be 0,1,2,3 depending on the kind of msg to be sent"
        },
        { bits: "7:0",
          name: "Message_Id",
          desc: "unique identifier for each command availabe in the protocol pointed by protocol_id"
        }
      ],
    },
    { name: "Message_Payload_1_c58",
      desc: "memory region dedicated to the parameters of the commands and their returns",
      swaccess: "rw",
      hwaccess: "none",
      fields: [
        { bits: "31:0" }
      ],
    },
    { name: "Doorbell_c58",
      desc: "Rapresents the interrupt to be raised towards the platform",
      swaccess: "rw",
      hwaccess: "hro",
      fields: [
        { bits: "31:1",
          name: "Preserve_Mask",
          desc: "These bits must be constant to 0, not used with just one platform and one agent"
        },
        { bits: "0",
          name: "intr",
          desc: "Interrupt bit"
        }
      ],
    },
    { name:  "Completion_Interrupt_c58",
      desc: "Rapresent the interrupt the platform should raise when it finishes to execute the received command",
      swaccess: "rw",
      hwaccess: "hro",
      fields: [
        { bits: "31:1",
          name: "Preserve_Mask",
          desc: "These bits must be constant to 0, not used with just one platform and one agent"
        },
        { bits: "0",
          name: "intr",
          desc: "Interrupt bit"
        }
      ],
    },
    { name: "Reserved_1_c59",
      desc: "Reserved, must be 0",
      swaccess: "rw",
      hwaccess: "none",
      fields: [
        { bits: "31:0" }
      ],
    },
    { name: "Channel_Status_c59",
      desc: "Indicates which entity has access to the Shared Memory",
      swaccess: "rw",
      hwaccess: "none",
      fields: [
        { bits: "31:2" },
        { bits: "1",
          name: "channel_error",
          desc: "Must be 0 in absence of errors"
        },
        { bits: "0",
          name: "channel_free",
          desc: "If 1 the agent own the channel, if 0 the platform own the channel"
        }
      ],
    },
    { name: "Reserved_2_c59",
      desc: "Reserved, implementation defined (32 bits over 64)",
      swaccess: "rw",
      hwaccess: "none",
      fields: [
        { bits: "31:0" }
      ],
    },
    { name: "Reserved_3_c59",
      desc: "Reserved, implementation defined (32 bits over 64)",
      swaccess: "none",
      hwaccess: "none",
      fields: [
        { bits: "31:0" }
      ],
    },
    { name: "Channel_Flags_c59",
      desc: "Defines wheter interrupts or polling is used for communication",
      swaccess: "rw",
      hwaccess: "none",
      fields: [
        { bits: "31:1" },
        { bits: "0",
          name: "intr_enable",
          desc: "If 1 interruts are used, if 0 polling is used"
        }
      ],
    },
    { name: "Length_c59",
      desc: "Lenght of payload + header",
      swaccess: "rw",
      hwaccess: "none",
      fields: [
        { bits: "31:0" }
      ],
    },
    { name: "Message_Header_c59",
      desc: "Defines which commanad the message contains",
      swaccess: "rw",
      hwaccess: "none",
      fields: [
        { bits: "31:28" },
        { bits: "27:18",
          name: "Token",
          desc: "must be same for the msg responses associated to a msg whith the same header"
        },
        { bits: "17:10",
          name: "Protocol_Id",
          desc: "Identifies to which protocol the command belongs to"
        },
        { bits: "9:8",
          name: "Message_Type",
          desc: "can be 0,1,2,3 depending on the kind of msg to be sent"
        },
        { bits: "7:0",
          name: "Message_Id",
          desc: "unique identifier for each command availabe in the protocol pointed by protocol_id"
        }
      ],
    },
    { name: "Message_Payload_1_c59",
      desc: "memory region dedicated to the parameters of the commands and their returns",
      swaccess: "rw",
      hwaccess: "none",
      fields: [
        { bits: "31:0" }
      ],
    },
    { name: "Doorbell_c59",
      desc: "Rapresents the interrupt to be raised towards the platform",
      swaccess: "rw",
      hwaccess: "hro",
      fields: [
        { bits: "31:1",
          name: "Preserve_Mask",
          desc: "These bits must be constant to 0, not used with just one platform and one agent"
        },
        { bits: "0",
          name: "intr",
          desc: "Interrupt bit"
        }
      ],
    },
    { name:  "Completion_Interrupt_c59",
      desc: "Rapresent the interrupt the platform should raise when it finishes to execute the received command",
      swaccess: "rw",
      hwaccess: "hro",
      fields: [
        { bits: "31:1",
          name: "Preserve_Mask",
          desc: "These bits must be constant to 0, not used with just one platform and one agent"
        },
        { bits: "0",
          name: "intr",
          desc: "Interrupt bit"
        }
      ],
    },
    { name: "Reserved_1_c60",
      desc: "Reserved, must be 0",
      swaccess: "rw",
      hwaccess: "none",
      fields: [
        { bits: "31:0" }
      ],
    },
    { name: "Channel_Status_c60",
      desc: "Indicates which entity has access to the Shared Memory",
      swaccess: "rw",
      hwaccess: "none",
      fields: [
        { bits: "31:2" },
        { bits: "1",
          name: "channel_error",
          desc: "Must be 0 in absence of errors"
        },
        { bits: "0",
          name: "channel_free",
          desc: "If 1 the agent own the channel, if 0 the platform own the channel"
        }
      ],
    },
    { name: "Reserved_2_c60",
      desc: "Reserved, implementation defined (32 bits over 64)",
      swaccess: "rw",
      hwaccess: "none",
      fields: [
        { bits: "31:0" }
      ],
    },
    { name: "Reserved_3_c60",
      desc: "Reserved, implementation defined (32 bits over 64)",
      swaccess: "none",
      hwaccess: "none",
      fields: [
        { bits: "31:0" }
      ],
    },
    { name: "Channel_Flags_c60",
      desc: "Defines wheter interrupts or polling is used for communication",
      swaccess: "rw",
      hwaccess: "none",
      fields: [
        { bits: "31:1" },
        { bits: "0",
          name: "intr_enable",
          desc: "If 1 interruts are used, if 0 polling is used"
        }
      ],
    },
    { name: "Length_c60",
      desc: "Lenght of payload + header",
      swaccess: "rw",
      hwaccess: "none",
      fields: [
        { bits: "31:0" }
      ],
    },
    { name: "Message_Header_c60",
      desc: "Defines which commanad the message contains",
      swaccess: "rw",
      hwaccess: "none",
      fields: [
        { bits: "31:28" },
        { bits: "27:18",
          name: "Token",
          desc: "must be same for the msg responses associated to a msg whith the same header"
        },
        { bits: "17:10",
          name: "Protocol_Id",
          desc: "Identifies to which protocol the command belongs to"
        },
        { bits: "9:8",
          name: "Message_Type",
          desc: "can be 0,1,2,3 depending on the kind of msg to be sent"
        },
        { bits: "7:0",
          name: "Message_Id",
          desc: "unique identifier for each command availabe in the protocol pointed by protocol_id"
        }
      ],
    },
    { name: "Message_Payload_1_c60",
      desc: "memory region dedicated to the parameters of the commands and their returns",
      swaccess: "rw",
      hwaccess: "none",
      fields: [
        { bits: "31:0" }
      ],
    },
    { name: "Doorbell_c60",
      desc: "Rapresents the interrupt to be raised towards the platform",
      swaccess: "rw",
      hwaccess: "hro",
      fields: [
        { bits: "31:1",
          name: "Preserve_Mask",
          desc: "These bits must be constant to 0, not used with just one platform and one agent"
        },
        { bits: "0",
          name: "intr",
          desc: "Interrupt bit"
        }
      ],
    },
    { name:  "Completion_Interrupt_c60",
      desc: "Rapresent the interrupt the platform should raise when it finishes to execute the received command",
      swaccess: "rw",
      hwaccess: "hro",
      fields: [
        { bits: "31:1",
          name: "Preserve_Mask",
          desc: "These bits must be constant to 0, not used with just one platform and one agent"
        },
        { bits: "0",
          name: "intr",
          desc: "Interrupt bit"
        }
      ],
    },
    { name: "Reserved_1_c61",
      desc: "Reserved, must be 0",
      swaccess: "rw",
      hwaccess: "none",
      fields: [
        { bits: "31:0" }
      ],
    },
    { name: "Channel_Status_c61",
      desc: "Indicates which entity has access to the Shared Memory",
      swaccess: "rw",
      hwaccess: "none",
      fields: [
        { bits: "31:2" },
        { bits: "1",
          name: "channel_error",
          desc: "Must be 0 in absence of errors"
        },
        { bits: "0",
          name: "channel_free",
          desc: "If 1 the agent own the channel, if 0 the platform own the channel"
        }
      ],
    },
    { name: "Reserved_2_c61",
      desc: "Reserved, implementation defined (32 bits over 64)",
      swaccess: "rw",
      hwaccess: "none",
      fields: [
        { bits: "31:0" }
      ],
    },
    { name: "Reserved_3_c61",
      desc: "Reserved, implementation defined (32 bits over 64)",
      swaccess: "none",
      hwaccess: "none",
      fields: [
        { bits: "31:0" }
      ],
    },
    { name: "Channel_Flags_c61",
      desc: "Defines wheter interrupts or polling is used for communication",
      swaccess: "rw",
      hwaccess: "none",
      fields: [
        { bits: "31:1" },
        { bits: "0",
          name: "intr_enable",
          desc: "If 1 interruts are used, if 0 polling is used"
        }
      ],
    },
    { name: "Length_c61",
      desc: "Lenght of payload + header",
      swaccess: "rw",
      hwaccess: "none",
      fields: [
        { bits: "31:0" }
      ],
    },
    { name: "Message_Header_c61",
      desc: "Defines which commanad the message contains",
      swaccess: "rw",
      hwaccess: "none",
      fields: [
        { bits: "31:28" },
        { bits: "27:18",
          name: "Token",
          desc: "must be same for the msg responses associated to a msg whith the same header"
        },
        { bits: "17:10",
          name: "Protocol_Id",
          desc: "Identifies to which protocol the command belongs to"
        },
        { bits: "9:8",
          name: "Message_Type",
          desc: "can be 0,1,2,3 depending on the kind of msg to be sent"
        },
        { bits: "7:0",
          name: "Message_Id",
          desc: "unique identifier for each command availabe in the protocol pointed by protocol_id"
        }
      ],
    },
    { name: "Message_Payload_1_c61",
      desc: "memory region dedicated to the parameters of the commands and their returns",
      swaccess: "rw",
      hwaccess: "none",
      fields: [
        { bits: "31:0" }
      ],
    },
    { name: "Doorbell_c61",
      desc: "Rapresents the interrupt to be raised towards the platform",
      swaccess: "rw",
      hwaccess: "hro",
      fields: [
        { bits: "31:1",
          name: "Preserve_Mask",
          desc: "These bits must be constant to 0, not used with just one platform and one agent"
        },
        { bits: "0",
          name: "intr",
          desc: "Interrupt bit"
        }
      ],
    },
    { name:  "Completion_Interrupt_c61",
      desc: "Rapresent the interrupt the platform should raise when it finishes to execute the received command",
      swaccess: "rw",
      hwaccess: "hro",
      fields: [
        { bits: "31:1",
          name: "Preserve_Mask",
          desc: "These bits must be constant to 0, not used with just one platform and one agent"
        },
        { bits: "0",
          name: "intr",
          desc: "Interrupt bit"
        }
      ],
    },
    { name: "Reserved_1_c62",
      desc: "Reserved, must be 0",
      swaccess: "rw",
      hwaccess: "none",
      fields: [
        { bits: "31:0" }
      ],
    },
    { name: "Channel_Status_c62",
      desc: "Indicates which entity has access to the Shared Memory",
      swaccess: "rw",
      hwaccess: "none",
      fields: [
        { bits: "31:2" },
        { bits: "1",
          name: "channel_error",
          desc: "Must be 0 in absence of errors"
        },
        { bits: "0",
          name: "channel_free",
          desc: "If 1 the agent own the channel, if 0 the platform own the channel"
        }
      ],
    },
    { name: "Reserved_2_c62",
      desc: "Reserved, implementation defined (32 bits over 64)",
      swaccess: "rw",
      hwaccess: "none",
      fields: [
        { bits: "31:0" }
      ],
    },
    { name: "Reserved_3_c62",
      desc: "Reserved, implementation defined (32 bits over 64)",
      swaccess: "none",
      hwaccess: "none",
      fields: [
        { bits: "31:0" }
      ],
    },
    { name: "Channel_Flags_c62",
      desc: "Defines wheter interrupts or polling is used for communication",
      swaccess: "rw",
      hwaccess: "none",
      fields: [
        { bits: "31:1" },
        { bits: "0",
          name: "intr_enable",
          desc: "If 1 interruts are used, if 0 polling is used"
        }
      ],
    },
    { name: "Length_c62",
      desc: "Lenght of payload + header",
      swaccess: "rw",
      hwaccess: "none",
      fields: [
        { bits: "31:0" }
      ],
    },
    { name: "Message_Header_c62",
      desc: "Defines which commanad the message contains",
      swaccess: "rw",
      hwaccess: "none",
      fields: [
        { bits: "31:28" },
        { bits: "27:18",
          name: "Token",
          desc: "must be same for the msg responses associated to a msg whith the same header"
        },
        { bits: "17:10",
          name: "Protocol_Id",
          desc: "Identifies to which protocol the command belongs to"
        },
        { bits: "9:8",
          name: "Message_Type",
          desc: "can be 0,1,2,3 depending on the kind of msg to be sent"
        },
        { bits: "7:0",
          name: "Message_Id",
          desc: "unique identifier for each command availabe in the protocol pointed by protocol_id"
        }
      ],
    },
    { name: "Message_Payload_1_c62",
      desc: "memory region dedicated to the parameters of the commands and their returns",
      swaccess: "rw",
      hwaccess: "none",
      fields: [
        { bits: "31:0" }
      ],
    },
    { name: "Doorbell_c62",
      desc: "Rapresents the interrupt to be raised towards the platform",
      swaccess: "rw",
      hwaccess: "hro",
      fields: [
        { bits: "31:1",
          name: "Preserve_Mask",
          desc: "These bits must be constant to 0, not used with just one platform and one agent"
        },
        { bits: "0",
          name: "intr",
          desc: "Interrupt bit"
        }
      ],
    },
    { name:  "Completion_Interrupt_c62",
      desc: "Rapresent the interrupt the platform should raise when it finishes to execute the received command",
      swaccess: "rw",
      hwaccess: "hro",
      fields: [
        { bits: "31:1",
          name: "Preserve_Mask",
          desc: "These bits must be constant to 0, not used with just one platform and one agent"
        },
        { bits: "0",
          name: "intr",
          desc: "Interrupt bit"
        }
      ],
    },
    { name: "Reserved_1_c63",
      desc: "Reserved, must be 0",
      swaccess: "rw",
      hwaccess: "none",
      fields: [
        { bits: "31:0" }
      ],
    },
    { name: "Channel_Status_c63",
      desc: "Indicates which entity has access to the Shared Memory",
      swaccess: "rw",
      hwaccess: "none",
      fields: [
        { bits: "31:2" },
        { bits: "1",
          name: "channel_error",
          desc: "Must be 0 in absence of errors"
        },
        { bits: "0",
          name: "channel_free",
          desc: "If 1 the agent own the channel, if 0 the platform own the channel"
        }
      ],
    },
    { name: "Reserved_2_c63",
      desc: "Reserved, implementation defined (32 bits over 64)",
      swaccess: "rw",
      hwaccess: "none",
      fields: [
        { bits: "31:0" }
      ],
    },
    { name: "Reserved_3_c63",
      desc: "Reserved, implementation defined (32 bits over 64)",
      swaccess: "none",
      hwaccess: "none",
      fields: [
        { bits: "31:0" }
      ],
    },
    { name: "Channel_Flags_c63",
      desc: "Defines wheter interrupts or polling is used for communication",
      swaccess: "rw",
      hwaccess: "none",
      fields: [
        { bits: "31:1" },
        { bits: "0",
          name: "intr_enable",
          desc: "If 1 interruts are used, if 0 polling is used"
        }
      ],
    },
    { name: "Length_c63",
      desc: "Lenght of payload + header",
      swaccess: "rw",
      hwaccess: "none",
      fields: [
        { bits: "31:0" }
      ],
    },
    { name: "Message_Header_c63",
      desc: "Defines which commanad the message contains",
      swaccess: "rw",
      hwaccess: "none",
      fields: [
        { bits: "31:28" },
        { bits: "27:18",
          name: "Token",
          desc: "must be same for the msg responses associated to a msg whith the same header"
        },
        { bits: "17:10",
          name: "Protocol_Id",
          desc: "Identifies to which protocol the command belongs to"
        },
        { bits: "9:8",
          name: "Message_Type",
          desc: "can be 0,1,2,3 depending on the kind of msg to be sent"
        },
        { bits: "7:0",
          name: "Message_Id",
          desc: "unique identifier for each command availabe in the protocol pointed by protocol_id"
        }
      ],
    },
    { name: "Message_Payload_1_c63",
      desc: "memory region dedicated to the parameters of the commands and their returns",
      swaccess: "rw",
      hwaccess: "none",
      fields: [
        { bits: "31:0" }
      ],
    },
    { name: "Doorbell_c63",
      desc: "Rapresents the interrupt to be raised towards the platform",
      swaccess: "rw",
      hwaccess: "hro",
      fields: [
        { bits: "31:1",
          name: "Preserve_Mask",
          desc: "These bits must be constant to 0, not used with just one platform and one agent"
        },
        { bits: "0",
          name: "intr",
          desc: "Interrupt bit"
        }
      ],
    },
    { name:  "Completion_Interrupt_c63",
      desc: "Rapresent the interrupt the platform should raise when it finishes to execute the received command",
      swaccess: "rw",
      hwaccess: "hro",
      fields: [
        { bits: "31:1",
          name: "Preserve_Mask",
          desc: "These bits must be constant to 0, not used with just one platform and one agent"
        },
        { bits: "0",
          name: "intr",
          desc: "Interrupt bit"
        }
      ],
    },
    { name: "Reserved_1_c64",
      desc: "Reserved, must be 0",
      swaccess: "rw",
      hwaccess: "none",
      fields: [
        { bits: "31:0" }
      ],
    },
    { name: "Channel_Status_c64",
      desc: "Indicates which entity has access to the Shared Memory",
      swaccess: "rw",
      hwaccess: "none",
      fields: [
        { bits: "31:2" },
        { bits: "1",
          name: "channel_error",
          desc: "Must be 0 in absence of errors"
        },
        { bits: "0",
          name: "channel_free",
          desc: "If 1 the agent own the channel, if 0 the platform own the channel"
        }
      ],
    },
    { name: "Reserved_2_c64",
      desc: "Reserved, implementation defined (32 bits over 64)",
      swaccess: "rw",
      hwaccess: "none",
      fields: [
        { bits: "31:0" }
      ],
    },
    { name: "Reserved_3_c64",
      desc: "Reserved, implementation defined (32 bits over 64)",
      swaccess: "none",
      hwaccess: "none",
      fields: [
        { bits: "31:0" }
      ],
    },
    { name: "Channel_Flags_c64",
      desc: "Defines wheter interrupts or polling is used for communication",
      swaccess: "rw",
      hwaccess: "none",
      fields: [
        { bits: "31:1" },
        { bits: "0",
          name: "intr_enable",
          desc: "If 1 interruts are used, if 0 polling is used"
        }
      ],
    },
    { name: "Length_c64",
      desc: "Lenght of payload + header",
      swaccess: "rw",
      hwaccess: "none",
      fields: [
        { bits: "31:0" }
      ],
    },
    { name: "Message_Header_c64",
      desc: "Defines which commanad the message contains",
      swaccess: "rw",
      hwaccess: "none",
      fields: [
        { bits: "31:28" },
        { bits: "27:18",
          name: "Token",
          desc: "must be same for the msg responses associated to a msg whith the same header"
        },
        { bits: "17:10",
          name: "Protocol_Id",
          desc: "Identifies to which protocol the command belongs to"
        },
        { bits: "9:8",
          name: "Message_Type",
          desc: "can be 0,1,2,3 depending on the kind of msg to be sent"
        },
        { bits: "7:0",
          name: "Message_Id",
          desc: "unique identifier for each command availabe in the protocol pointed by protocol_id"
        }
      ],
    },
    { name: "Message_Payload_1_c64",
      desc: "memory region dedicated to the parameters of the commands and their returns",
      swaccess: "rw",
      hwaccess: "none",
      fields: [
        { bits: "31:0" }
      ],
    },
    { name: "Doorbell_c64",
      desc: "Rapresents the interrupt to be raised towards the platform",
      swaccess: "rw",
      hwaccess: "hro",
      fields: [
        { bits: "31:1",
          name: "Preserve_Mask",
          desc: "These bits must be constant to 0, not used with just one platform and one agent"
        },
        { bits: "0",
          name: "intr",
          desc: "Interrupt bit"
        }
      ],
    },
    { name:  "Completion_Interrupt_c64",
      desc: "Rapresent the interrupt the platform should raise when it finishes to execute the received command",
      swaccess: "rw",
      hwaccess: "hro",
      fields: [
        { bits: "31:1",
          name: "Preserve_Mask",
          desc: "These bits must be constant to 0, not used with just one platform and one agent"
        },
        { bits: "0",
          name: "intr",
          desc: "Interrupt bit"
        }
      ],
    },
    { name: "Reserved_1_c65",
      desc: "Reserved, must be 0",
      swaccess: "rw",
      hwaccess: "none",
      fields: [
        { bits: "31:0" }
      ],
    },
    { name: "Channel_Status_c65",
      desc: "Indicates which entity has access to the Shared Memory",
      swaccess: "rw",
      hwaccess: "none",
      fields: [
        { bits: "31:2" },
        { bits: "1",
          name: "channel_error",
          desc: "Must be 0 in absence of errors"
        },
        { bits: "0",
          name: "channel_free",
          desc: "If 1 the agent own the channel, if 0 the platform own the channel"
        }
      ],
    },
    { name: "Reserved_2_c65",
      desc: "Reserved, implementation defined (32 bits over 64)",
      swaccess: "rw",
      hwaccess: "none",
      fields: [
        { bits: "31:0" }
      ],
    },
    { name: "Reserved_3_c65",
      desc: "Reserved, implementation defined (32 bits over 64)",
      swaccess: "none",
      hwaccess: "none",
      fields: [
        { bits: "31:0" }
      ],
    },
    { name: "Channel_Flags_c65",
      desc: "Defines wheter interrupts or polling is used for communication",
      swaccess: "rw",
      hwaccess: "none",
      fields: [
        { bits: "31:1" },
        { bits: "0",
          name: "intr_enable",
          desc: "If 1 interruts are used, if 0 polling is used"
        }
      ],
    },
    { name: "Length_c65",
      desc: "Lenght of payload + header",
      swaccess: "rw",
      hwaccess: "none",
      fields: [
        { bits: "31:0" }
      ],
    },
    { name: "Message_Header_c65",
      desc: "Defines which commanad the message contains",
      swaccess: "rw",
      hwaccess: "none",
      fields: [
        { bits: "31:28" },
        { bits: "27:18",
          name: "Token",
          desc: "must be same for the msg responses associated to a msg whith the same header"
        },
        { bits: "17:10",
          name: "Protocol_Id",
          desc: "Identifies to which protocol the command belongs to"
        },
        { bits: "9:8",
          name: "Message_Type",
          desc: "can be 0,1,2,3 depending on the kind of msg to be sent"
        },
        { bits: "7:0",
          name: "Message_Id",
          desc: "unique identifier for each command availabe in the protocol pointed by protocol_id"
        }
      ],
    },
    { name: "Message_Payload_1_c65",
      desc: "memory region dedicated to the parameters of the commands and their returns",
      swaccess: "rw",
      hwaccess: "none",
      fields: [
        { bits: "31:0" }
      ],
    },
    { name: "Doorbell_c65",
      desc: "Rapresents the interrupt to be raised towards the platform",
      swaccess: "rw",
      hwaccess: "hro",
      fields: [
        { bits: "31:1",
          name: "Preserve_Mask",
          desc: "These bits must be constant to 0, not used with just one platform and one agent"
        },
        { bits: "0",
          name: "intr",
          desc: "Interrupt bit"
        }
      ],
    },
    { name:  "Completion_Interrupt_c65",
      desc: "Rapresent the interrupt the platform should raise when it finishes to execute the received command",
      swaccess: "rw",
      hwaccess: "hro",
      fields: [
        { bits: "31:1",
          name: "Preserve_Mask",
          desc: "These bits must be constant to 0, not used with just one platform and one agent"
        },
        { bits: "0",
          name: "intr",
          desc: "Interrupt bit"
        }
      ],
    },
    { name: "Reserved_1_c66",
      desc: "Reserved, must be 0",
      swaccess: "rw",
      hwaccess: "none",
      fields: [
        { bits: "31:0" }
      ],
    },
    { name: "Channel_Status_c66",
      desc: "Indicates which entity has access to the Shared Memory",
      swaccess: "rw",
      hwaccess: "none",
      fields: [
        { bits: "31:2" },
        { bits: "1",
          name: "channel_error",
          desc: "Must be 0 in absence of errors"
        },
        { bits: "0",
          name: "channel_free",
          desc: "If 1 the agent own the channel, if 0 the platform own the channel"
        }
      ],
    },
    { name: "Reserved_2_c66",
      desc: "Reserved, implementation defined (32 bits over 64)",
      swaccess: "rw",
      hwaccess: "none",
      fields: [
        { bits: "31:0" }
      ],
    },
    { name: "Reserved_3_c66",
      desc: "Reserved, implementation defined (32 bits over 64)",
      swaccess: "none",
      hwaccess: "none",
      fields: [
        { bits: "31:0" }
      ],
    },
    { name: "Channel_Flags_c66",
      desc: "Defines wheter interrupts or polling is used for communication",
      swaccess: "rw",
      hwaccess: "none",
      fields: [
        { bits: "31:1" },
        { bits: "0",
          name: "intr_enable",
          desc: "If 1 interruts are used, if 0 polling is used"
        }
      ],
    },
    { name: "Length_c66",
      desc: "Lenght of payload + header",
      swaccess: "rw",
      hwaccess: "none",
      fields: [
        { bits: "31:0" }
      ],
    },
    { name: "Message_Header_c66",
      desc: "Defines which commanad the message contains",
      swaccess: "rw",
      hwaccess: "none",
      fields: [
        { bits: "31:28" },
        { bits: "27:18",
          name: "Token",
          desc: "must be same for the msg responses associated to a msg whith the same header"
        },
        { bits: "17:10",
          name: "Protocol_Id",
          desc: "Identifies to which protocol the command belongs to"
        },
        { bits: "9:8",
          name: "Message_Type",
          desc: "can be 0,1,2,3 depending on the kind of msg to be sent"
        },
        { bits: "7:0",
          name: "Message_Id",
          desc: "unique identifier for each command availabe in the protocol pointed by protocol_id"
        }
      ],
    },
    { name: "Message_Payload_1_c66",
      desc: "memory region dedicated to the parameters of the commands and their returns",
      swaccess: "rw",
      hwaccess: "none",
      fields: [
        { bits: "31:0" }
      ],
    },
    { name: "Doorbell_c66",
      desc: "Rapresents the interrupt to be raised towards the platform",
      swaccess: "rw",
      hwaccess: "hro",
      fields: [
        { bits: "31:1",
          name: "Preserve_Mask",
          desc: "These bits must be constant to 0, not used with just one platform and one agent"
        },
        { bits: "0",
          name: "intr",
          desc: "Interrupt bit"
        }
      ],
    },
    { name:  "Completion_Interrupt_c66",
      desc: "Rapresent the interrupt the platform should raise when it finishes to execute the received command",
      swaccess: "rw",
      hwaccess: "hro",
      fields: [
        { bits: "31:1",
          name: "Preserve_Mask",
          desc: "These bits must be constant to 0, not used with just one platform and one agent"
        },
        { bits: "0",
          name: "intr",
          desc: "Interrupt bit"
        }
      ],
    },
    { name: "Reserved_1_c67",
      desc: "Reserved, must be 0",
      swaccess: "rw",
      hwaccess: "none",
      fields: [
        { bits: "31:0" }
      ],
    },
    { name: "Channel_Status_c67",
      desc: "Indicates which entity has access to the Shared Memory",
      swaccess: "rw",
      hwaccess: "none",
      fields: [
        { bits: "31:2" },
        { bits: "1",
          name: "channel_error",
          desc: "Must be 0 in absence of errors"
        },
        { bits: "0",
          name: "channel_free",
          desc: "If 1 the agent own the channel, if 0 the platform own the channel"
        }
      ],
    },
    { name: "Reserved_2_c67",
      desc: "Reserved, implementation defined (32 bits over 64)",
      swaccess: "rw",
      hwaccess: "none",
      fields: [
        { bits: "31:0" }
      ],
    },
    { name: "Reserved_3_c67",
      desc: "Reserved, implementation defined (32 bits over 64)",
      swaccess: "none",
      hwaccess: "none",
      fields: [
        { bits: "31:0" }
      ],
    },
    { name: "Channel_Flags_c67",
      desc: "Defines wheter interrupts or polling is used for communication",
      swaccess: "rw",
      hwaccess: "none",
      fields: [
        { bits: "31:1" },
        { bits: "0",
          name: "intr_enable",
          desc: "If 1 interruts are used, if 0 polling is used"
        }
      ],
    },
    { name: "Length_c67",
      desc: "Lenght of payload + header",
      swaccess: "rw",
      hwaccess: "none",
      fields: [
        { bits: "31:0" }
      ],
    },
    { name: "Message_Header_c67",
      desc: "Defines which commanad the message contains",
      swaccess: "rw",
      hwaccess: "none",
      fields: [
        { bits: "31:28" },
        { bits: "27:18",
          name: "Token",
          desc: "must be same for the msg responses associated to a msg whith the same header"
        },
        { bits: "17:10",
          name: "Protocol_Id",
          desc: "Identifies to which protocol the command belongs to"
        },
        { bits: "9:8",
          name: "Message_Type",
          desc: "can be 0,1,2,3 depending on the kind of msg to be sent"
        },
        { bits: "7:0",
          name: "Message_Id",
          desc: "unique identifier for each command availabe in the protocol pointed by protocol_id"
        }
      ],
    },
    { name: "Message_Payload_1_c67",
      desc: "memory region dedicated to the parameters of the commands and their returns",
      swaccess: "rw",
      hwaccess: "none",
      fields: [
        { bits: "31:0" }
      ],
    },
    { name: "Doorbell_c67",
      desc: "Rapresents the interrupt to be raised towards the platform",
      swaccess: "rw",
      hwaccess: "hro",
      fields: [
        { bits: "31:1",
          name: "Preserve_Mask",
          desc: "These bits must be constant to 0, not used with just one platform and one agent"
        },
        { bits: "0",
          name: "intr",
          desc: "Interrupt bit"
        }
      ],
    },
    { name:  "Completion_Interrupt_c67",
      desc: "Rapresent the interrupt the platform should raise when it finishes to execute the received command",
      swaccess: "rw",
      hwaccess: "hro",
      fields: [
        { bits: "31:1",
          name: "Preserve_Mask",
          desc: "These bits must be constant to 0, not used with just one platform and one agent"
        },
        { bits: "0",
          name: "intr",
          desc: "Interrupt bit"
        }
      ],
    },
    { name: "Reserved_1_c68",
      desc: "Reserved, must be 0",
      swaccess: "rw",
      hwaccess: "none",
      fields: [
        { bits: "31:0" }
      ],
    },
    { name: "Channel_Status_c68",
      desc: "Indicates which entity has access to the Shared Memory",
      swaccess: "rw",
      hwaccess: "none",
      fields: [
        { bits: "31:2" },
        { bits: "1",
          name: "channel_error",
          desc: "Must be 0 in absence of errors"
        },
        { bits: "0",
          name: "channel_free",
          desc: "If 1 the agent own the channel, if 0 the platform own the channel"
        }
      ],
    },
    { name: "Reserved_2_c68",
      desc: "Reserved, implementation defined (32 bits over 64)",
      swaccess: "rw",
      hwaccess: "none",
      fields: [
        { bits: "31:0" }
      ],
    },
    { name: "Reserved_3_c68",
      desc: "Reserved, implementation defined (32 bits over 64)",
      swaccess: "none",
      hwaccess: "none",
      fields: [
        { bits: "31:0" }
      ],
    },
    { name: "Channel_Flags_c68",
      desc: "Defines wheter interrupts or polling is used for communication",
      swaccess: "rw",
      hwaccess: "none",
      fields: [
        { bits: "31:1" },
        { bits: "0",
          name: "intr_enable",
          desc: "If 1 interruts are used, if 0 polling is used"
        }
      ],
    },
    { name: "Length_c68",
      desc: "Lenght of payload + header",
      swaccess: "rw",
      hwaccess: "none",
      fields: [
        { bits: "31:0" }
      ],
    },
    { name: "Message_Header_c68",
      desc: "Defines which commanad the message contains",
      swaccess: "rw",
      hwaccess: "none",
      fields: [
        { bits: "31:28" },
        { bits: "27:18",
          name: "Token",
          desc: "must be same for the msg responses associated to a msg whith the same header"
        },
        { bits: "17:10",
          name: "Protocol_Id",
          desc: "Identifies to which protocol the command belongs to"
        },
        { bits: "9:8",
          name: "Message_Type",
          desc: "can be 0,1,2,3 depending on the kind of msg to be sent"
        },
        { bits: "7:0",
          name: "Message_Id",
          desc: "unique identifier for each command availabe in the protocol pointed by protocol_id"
        }
      ],
    },
    { name: "Message_Payload_1_c68",
      desc: "memory region dedicated to the parameters of the commands and their returns",
      swaccess: "rw",
      hwaccess: "none",
      fields: [
        { bits: "31:0" }
      ],
    },
    { name: "Doorbell_c68",
      desc: "Rapresents the interrupt to be raised towards the platform",
      swaccess: "rw",
      hwaccess: "hro",
      fields: [
        { bits: "31:1",
          name: "Preserve_Mask",
          desc: "These bits must be constant to 0, not used with just one platform and one agent"
        },
        { bits: "0",
          name: "intr",
          desc: "Interrupt bit"
        }
      ],
    },
    { name:  "Completion_Interrupt_c68",
      desc: "Rapresent the interrupt the platform should raise when it finishes to execute the received command",
      swaccess: "rw",
      hwaccess: "hro",
      fields: [
        { bits: "31:1",
          name: "Preserve_Mask",
          desc: "These bits must be constant to 0, not used with just one platform and one agent"
        },
        { bits: "0",
          name: "intr",
          desc: "Interrupt bit"
        }
      ],
    },
    { name: "Reserved_1_c69",
      desc: "Reserved, must be 0",
      swaccess: "rw",
      hwaccess: "none",
      fields: [
        { bits: "31:0" }
      ],
    },
    { name: "Channel_Status_c69",
      desc: "Indicates which entity has access to the Shared Memory",
      swaccess: "rw",
      hwaccess: "none",
      fields: [
        { bits: "31:2" },
        { bits: "1",
          name: "channel_error",
          desc: "Must be 0 in absence of errors"
        },
        { bits: "0",
          name: "channel_free",
          desc: "If 1 the agent own the channel, if 0 the platform own the channel"
        }
      ],
    },
    { name: "Reserved_2_c69",
      desc: "Reserved, implementation defined (32 bits over 64)",
      swaccess: "rw",
      hwaccess: "none",
      fields: [
        { bits: "31:0" }
      ],
    },
    { name: "Reserved_3_c69",
      desc: "Reserved, implementation defined (32 bits over 64)",
      swaccess: "none",
      hwaccess: "none",
      fields: [
        { bits: "31:0" }
      ],
    },
    { name: "Channel_Flags_c69",
      desc: "Defines wheter interrupts or polling is used for communication",
      swaccess: "rw",
      hwaccess: "none",
      fields: [
        { bits: "31:1" },
        { bits: "0",
          name: "intr_enable",
          desc: "If 1 interruts are used, if 0 polling is used"
        }
      ],
    },
    { name: "Length_c69",
      desc: "Lenght of payload + header",
      swaccess: "rw",
      hwaccess: "none",
      fields: [
        { bits: "31:0" }
      ],
    },
    { name: "Message_Header_c69",
      desc: "Defines which commanad the message contains",
      swaccess: "rw",
      hwaccess: "none",
      fields: [
        { bits: "31:28" },
        { bits: "27:18",
          name: "Token",
          desc: "must be same for the msg responses associated to a msg whith the same header"
        },
        { bits: "17:10",
          name: "Protocol_Id",
          desc: "Identifies to which protocol the command belongs to"
        },
        { bits: "9:8",
          name: "Message_Type",
          desc: "can be 0,1,2,3 depending on the kind of msg to be sent"
        },
        { bits: "7:0",
          name: "Message_Id",
          desc: "unique identifier for each command availabe in the protocol pointed by protocol_id"
        }
      ],
    },
    { name: "Message_Payload_1_c69",
      desc: "memory region dedicated to the parameters of the commands and their returns",
      swaccess: "rw",
      hwaccess: "none",
      fields: [
        { bits: "31:0" }
      ],
    },
    { name: "Doorbell_c69",
      desc: "Rapresents the interrupt to be raised towards the platform",
      swaccess: "rw",
      hwaccess: "hro",
      fields: [
        { bits: "31:1",
          name: "Preserve_Mask",
          desc: "These bits must be constant to 0, not used with just one platform and one agent"
        },
        { bits: "0",
          name: "intr",
          desc: "Interrupt bit"
        }
      ],
    },
    { name:  "Completion_Interrupt_c69",
      desc: "Rapresent the interrupt the platform should raise when it finishes to execute the received command",
      swaccess: "rw",
      hwaccess: "hro",
      fields: [
        { bits: "31:1",
          name: "Preserve_Mask",
          desc: "These bits must be constant to 0, not used with just one platform and one agent"
        },
        { bits: "0",
          name: "intr",
          desc: "Interrupt bit"
        }
      ],
    },
    { name: "Reserved_1_c70",
      desc: "Reserved, must be 0",
      swaccess: "rw",
      hwaccess: "none",
      fields: [
        { bits: "31:0" }
      ],
    },
    { name: "Channel_Status_c70",
      desc: "Indicates which entity has access to the Shared Memory",
      swaccess: "rw",
      hwaccess: "none",
      fields: [
        { bits: "31:2" },
        { bits: "1",
          name: "channel_error",
          desc: "Must be 0 in absence of errors"
        },
        { bits: "0",
          name: "channel_free",
          desc: "If 1 the agent own the channel, if 0 the platform own the channel"
        }
      ],
    },
    { name: "Reserved_2_c70",
      desc: "Reserved, implementation defined (32 bits over 64)",
      swaccess: "rw",
      hwaccess: "none",
      fields: [
        { bits: "31:0" }
      ],
    },
    { name: "Reserved_3_c70",
      desc: "Reserved, implementation defined (32 bits over 64)",
      swaccess: "none",
      hwaccess: "none",
      fields: [
        { bits: "31:0" }
      ],
    },
    { name: "Channel_Flags_c70",
      desc: "Defines wheter interrupts or polling is used for communication",
      swaccess: "rw",
      hwaccess: "none",
      fields: [
        { bits: "31:1" },
        { bits: "0",
          name: "intr_enable",
          desc: "If 1 interruts are used, if 0 polling is used"
        }
      ],
    },
    { name: "Length_c70",
      desc: "Lenght of payload + header",
      swaccess: "rw",
      hwaccess: "none",
      fields: [
        { bits: "31:0" }
      ],
    },
    { name: "Message_Header_c70",
      desc: "Defines which commanad the message contains",
      swaccess: "rw",
      hwaccess: "none",
      fields: [
        { bits: "31:28" },
        { bits: "27:18",
          name: "Token",
          desc: "must be same for the msg responses associated to a msg whith the same header"
        },
        { bits: "17:10",
          name: "Protocol_Id",
          desc: "Identifies to which protocol the command belongs to"
        },
        { bits: "9:8",
          name: "Message_Type",
          desc: "can be 0,1,2,3 depending on the kind of msg to be sent"
        },
        { bits: "7:0",
          name: "Message_Id",
          desc: "unique identifier for each command availabe in the protocol pointed by protocol_id"
        }
      ],
    },
    { name: "Message_Payload_1_c70",
      desc: "memory region dedicated to the parameters of the commands and their returns",
      swaccess: "rw",
      hwaccess: "none",
      fields: [
        { bits: "31:0" }
      ],
    },
    { name: "Doorbell_c70",
      desc: "Rapresents the interrupt to be raised towards the platform",
      swaccess: "rw",
      hwaccess: "hro",
      fields: [
        { bits: "31:1",
          name: "Preserve_Mask",
          desc: "These bits must be constant to 0, not used with just one platform and one agent"
        },
        { bits: "0",
          name: "intr",
          desc: "Interrupt bit"
        }
      ],
    },
    { name:  "Completion_Interrupt_c70",
      desc: "Rapresent the interrupt the platform should raise when it finishes to execute the received command",
      swaccess: "rw",
      hwaccess: "hro",
      fields: [
        { bits: "31:1",
          name: "Preserve_Mask",
          desc: "These bits must be constant to 0, not used with just one platform and one agent"
        },
        { bits: "0",
          name: "intr",
          desc: "Interrupt bit"
        }
      ],
    },
    { name: "Reserved_1_c71",
      desc: "Reserved, must be 0",
      swaccess: "rw",
      hwaccess: "none",
      fields: [
        { bits: "31:0" }
      ],
    },
    { name: "Channel_Status_c71",
      desc: "Indicates which entity has access to the Shared Memory",
      swaccess: "rw",
      hwaccess: "none",
      fields: [
        { bits: "31:2" },
        { bits: "1",
          name: "channel_error",
          desc: "Must be 0 in absence of errors"
        },
        { bits: "0",
          name: "channel_free",
          desc: "If 1 the agent own the channel, if 0 the platform own the channel"
        }
      ],
    },
    { name: "Reserved_2_c71",
      desc: "Reserved, implementation defined (32 bits over 64)",
      swaccess: "rw",
      hwaccess: "none",
      fields: [
        { bits: "31:0" }
      ],
    },
    { name: "Reserved_3_c71",
      desc: "Reserved, implementation defined (32 bits over 64)",
      swaccess: "none",
      hwaccess: "none",
      fields: [
        { bits: "31:0" }
      ],
    },
    { name: "Channel_Flags_c71",
      desc: "Defines wheter interrupts or polling is used for communication",
      swaccess: "rw",
      hwaccess: "none",
      fields: [
        { bits: "31:1" },
        { bits: "0",
          name: "intr_enable",
          desc: "If 1 interruts are used, if 0 polling is used"
        }
      ],
    },
    { name: "Length_c71",
      desc: "Lenght of payload + header",
      swaccess: "rw",
      hwaccess: "none",
      fields: [
        { bits: "31:0" }
      ],
    },
    { name: "Message_Header_c71",
      desc: "Defines which commanad the message contains",
      swaccess: "rw",
      hwaccess: "none",
      fields: [
        { bits: "31:28" },
        { bits: "27:18",
          name: "Token",
          desc: "must be same for the msg responses associated to a msg whith the same header"
        },
        { bits: "17:10",
          name: "Protocol_Id",
          desc: "Identifies to which protocol the command belongs to"
        },
        { bits: "9:8",
          name: "Message_Type",
          desc: "can be 0,1,2,3 depending on the kind of msg to be sent"
        },
        { bits: "7:0",
          name: "Message_Id",
          desc: "unique identifier for each command availabe in the protocol pointed by protocol_id"
        }
      ],
    },
    { name: "Message_Payload_1_c71",
      desc: "memory region dedicated to the parameters of the commands and their returns",
      swaccess: "rw",
      hwaccess: "none",
      fields: [
        { bits: "31:0" }
      ],
    },
    { name: "Doorbell_c71",
      desc: "Rapresents the interrupt to be raised towards the platform",
      swaccess: "rw",
      hwaccess: "hro",
      fields: [
        { bits: "31:1",
          name: "Preserve_Mask",
          desc: "These bits must be constant to 0, not used with just one platform and one agent"
        },
        { bits: "0",
          name: "intr",
          desc: "Interrupt bit"
        }
      ],
    },
    { name:  "Completion_Interrupt_c71",
      desc: "Rapresent the interrupt the platform should raise when it finishes to execute the received command",
      swaccess: "rw",
      hwaccess: "hro",
      fields: [
        { bits: "31:1",
          name: "Preserve_Mask",
          desc: "These bits must be constant to 0, not used with just one platform and one agent"
        },
        { bits: "0",
          name: "intr",
          desc: "Interrupt bit"
        }
      ],
    },
    { name: "Reserved_1_c72",
      desc: "Reserved, must be 0",
      swaccess: "rw",
      hwaccess: "none",
      fields: [
        { bits: "31:0" }
      ],
    },
    { name: "Channel_Status_c72",
      desc: "Indicates which entity has access to the Shared Memory",
      swaccess: "rw",
      hwaccess: "none",
      fields: [
        { bits: "31:2" },
        { bits: "1",
          name: "channel_error",
          desc: "Must be 0 in absence of errors"
        },
        { bits: "0",
          name: "channel_free",
          desc: "If 1 the agent own the channel, if 0 the platform own the channel"
        }
      ],
    },
    { name: "Reserved_2_c72",
      desc: "Reserved, implementation defined (32 bits over 64)",
      swaccess: "rw",
      hwaccess: "none",
      fields: [
        { bits: "31:0" }
      ],
    },
    { name: "Reserved_3_c72",
      desc: "Reserved, implementation defined (32 bits over 64)",
      swaccess: "none",
      hwaccess: "none",
      fields: [
        { bits: "31:0" }
      ],
    },
    { name: "Channel_Flags_c72",
      desc: "Defines wheter interrupts or polling is used for communication",
      swaccess: "rw",
      hwaccess: "none",
      fields: [
        { bits: "31:1" },
        { bits: "0",
          name: "intr_enable",
          desc: "If 1 interruts are used, if 0 polling is used"
        }
      ],
    },
    { name: "Length_c72",
      desc: "Lenght of payload + header",
      swaccess: "rw",
      hwaccess: "none",
      fields: [
        { bits: "31:0" }
      ],
    },
    { name: "Message_Header_c72",
      desc: "Defines which commanad the message contains",
      swaccess: "rw",
      hwaccess: "none",
      fields: [
        { bits: "31:28" },
        { bits: "27:18",
          name: "Token",
          desc: "must be same for the msg responses associated to a msg whith the same header"
        },
        { bits: "17:10",
          name: "Protocol_Id",
          desc: "Identifies to which protocol the command belongs to"
        },
        { bits: "9:8",
          name: "Message_Type",
          desc: "can be 0,1,2,3 depending on the kind of msg to be sent"
        },
        { bits: "7:0",
          name: "Message_Id",
          desc: "unique identifier for each command availabe in the protocol pointed by protocol_id"
        }
      ],
    },
    { name: "Message_Payload_1_c72",
      desc: "memory region dedicated to the parameters of the commands and their returns",
      swaccess: "rw",
      hwaccess: "none",
      fields: [
        { bits: "31:0" }
      ],
    },
    { name: "Doorbell_c72",
      desc: "Rapresents the interrupt to be raised towards the platform",
      swaccess: "rw",
      hwaccess: "hro",
      fields: [
        { bits: "31:1",
          name: "Preserve_Mask",
          desc: "These bits must be constant to 0, not used with just one platform and one agent"
        },
        { bits: "0",
          name: "intr",
          desc: "Interrupt bit"
        }
      ],
    },
    { name:  "Completion_Interrupt_c72",
      desc: "Rapresent the interrupt the platform should raise when it finishes to execute the received command",
      swaccess: "rw",
      hwaccess: "hro",
      fields: [
        { bits: "31:1",
          name: "Preserve_Mask",
          desc: "These bits must be constant to 0, not used with just one platform and one agent"
        },
        { bits: "0",
          name: "intr",
          desc: "Interrupt bit"
        }
      ],
    },
    { name: "Reserved_1_c73",
      desc: "Reserved, must be 0",
      swaccess: "rw",
      hwaccess: "none",
      fields: [
        { bits: "31:0" }
      ],
    },
    { name: "Channel_Status_c73",
      desc: "Indicates which entity has access to the Shared Memory",
      swaccess: "rw",
      hwaccess: "none",
      fields: [
        { bits: "31:2" },
        { bits: "1",
          name: "channel_error",
          desc: "Must be 0 in absence of errors"
        },
        { bits: "0",
          name: "channel_free",
          desc: "If 1 the agent own the channel, if 0 the platform own the channel"
        }
      ],
    },
    { name: "Reserved_2_c73",
      desc: "Reserved, implementation defined (32 bits over 64)",
      swaccess: "rw",
      hwaccess: "none",
      fields: [
        { bits: "31:0" }
      ],
    },
    { name: "Reserved_3_c73",
      desc: "Reserved, implementation defined (32 bits over 64)",
      swaccess: "none",
      hwaccess: "none",
      fields: [
        { bits: "31:0" }
      ],
    },
    { name: "Channel_Flags_c73",
      desc: "Defines wheter interrupts or polling is used for communication",
      swaccess: "rw",
      hwaccess: "none",
      fields: [
        { bits: "31:1" },
        { bits: "0",
          name: "intr_enable",
          desc: "If 1 interruts are used, if 0 polling is used"
        }
      ],
    },
    { name: "Length_c73",
      desc: "Lenght of payload + header",
      swaccess: "rw",
      hwaccess: "none",
      fields: [
        { bits: "31:0" }
      ],
    },
    { name: "Message_Header_c73",
      desc: "Defines which commanad the message contains",
      swaccess: "rw",
      hwaccess: "none",
      fields: [
        { bits: "31:28" },
        { bits: "27:18",
          name: "Token",
          desc: "must be same for the msg responses associated to a msg whith the same header"
        },
        { bits: "17:10",
          name: "Protocol_Id",
          desc: "Identifies to which protocol the command belongs to"
        },
        { bits: "9:8",
          name: "Message_Type",
          desc: "can be 0,1,2,3 depending on the kind of msg to be sent"
        },
        { bits: "7:0",
          name: "Message_Id",
          desc: "unique identifier for each command availabe in the protocol pointed by protocol_id"
        }
      ],
    },
    { name: "Message_Payload_1_c73",
      desc: "memory region dedicated to the parameters of the commands and their returns",
      swaccess: "rw",
      hwaccess: "none",
      fields: [
        { bits: "31:0" }
      ],
    },
    { name: "Doorbell_c73",
      desc: "Rapresents the interrupt to be raised towards the platform",
      swaccess: "rw",
      hwaccess: "hro",
      fields: [
        { bits: "31:1",
          name: "Preserve_Mask",
          desc: "These bits must be constant to 0, not used with just one platform and one agent"
        },
        { bits: "0",
          name: "intr",
          desc: "Interrupt bit"
        }
      ],
    },
    { name:  "Completion_Interrupt_c73",
      desc: "Rapresent the interrupt the platform should raise when it finishes to execute the received command",
      swaccess: "rw",
      hwaccess: "hro",
      fields: [
        { bits: "31:1",
          name: "Preserve_Mask",
          desc: "These bits must be constant to 0, not used with just one platform and one agent"
        },
        { bits: "0",
          name: "intr",
          desc: "Interrupt bit"
        }
      ],
    },
    { name: "Reserved_1_c74",
      desc: "Reserved, must be 0",
      swaccess: "rw",
      hwaccess: "none",
      fields: [
        { bits: "31:0" }
      ],
    },
    { name: "Channel_Status_c74",
      desc: "Indicates which entity has access to the Shared Memory",
      swaccess: "rw",
      hwaccess: "none",
      fields: [
        { bits: "31:2" },
        { bits: "1",
          name: "channel_error",
          desc: "Must be 0 in absence of errors"
        },
        { bits: "0",
          name: "channel_free",
          desc: "If 1 the agent own the channel, if 0 the platform own the channel"
        }
      ],
    },
    { name: "Reserved_2_c74",
      desc: "Reserved, implementation defined (32 bits over 64)",
      swaccess: "rw",
      hwaccess: "none",
      fields: [
        { bits: "31:0" }
      ],
    },
    { name: "Reserved_3_c74",
      desc: "Reserved, implementation defined (32 bits over 64)",
      swaccess: "none",
      hwaccess: "none",
      fields: [
        { bits: "31:0" }
      ],
    },
    { name: "Channel_Flags_c74",
      desc: "Defines wheter interrupts or polling is used for communication",
      swaccess: "rw",
      hwaccess: "none",
      fields: [
        { bits: "31:1" },
        { bits: "0",
          name: "intr_enable",
          desc: "If 1 interruts are used, if 0 polling is used"
        }
      ],
    },
    { name: "Length_c74",
      desc: "Lenght of payload + header",
      swaccess: "rw",
      hwaccess: "none",
      fields: [
        { bits: "31:0" }
      ],
    },
    { name: "Message_Header_c74",
      desc: "Defines which commanad the message contains",
      swaccess: "rw",
      hwaccess: "none",
      fields: [
        { bits: "31:28" },
        { bits: "27:18",
          name: "Token",
          desc: "must be same for the msg responses associated to a msg whith the same header"
        },
        { bits: "17:10",
          name: "Protocol_Id",
          desc: "Identifies to which protocol the command belongs to"
        },
        { bits: "9:8",
          name: "Message_Type",
          desc: "can be 0,1,2,3 depending on the kind of msg to be sent"
        },
        { bits: "7:0",
          name: "Message_Id",
          desc: "unique identifier for each command availabe in the protocol pointed by protocol_id"
        }
      ],
    },
    { name: "Message_Payload_1_c74",
      desc: "memory region dedicated to the parameters of the commands and their returns",
      swaccess: "rw",
      hwaccess: "none",
      fields: [
        { bits: "31:0" }
      ],
    },
    { name: "Doorbell_c74",
      desc: "Rapresents the interrupt to be raised towards the platform",
      swaccess: "rw",
      hwaccess: "hro",
      fields: [
        { bits: "31:1",
          name: "Preserve_Mask",
          desc: "These bits must be constant to 0, not used with just one platform and one agent"
        },
        { bits: "0",
          name: "intr",
          desc: "Interrupt bit"
        }
      ],
    },
    { name:  "Completion_Interrupt_c74",
      desc: "Rapresent the interrupt the platform should raise when it finishes to execute the received command",
      swaccess: "rw",
      hwaccess: "hro",
      fields: [
        { bits: "31:1",
          name: "Preserve_Mask",
          desc: "These bits must be constant to 0, not used with just one platform and one agent"
        },
        { bits: "0",
          name: "intr",
          desc: "Interrupt bit"
        }
      ],
    },
    { name: "Reserved_1_c75",
      desc: "Reserved, must be 0",
      swaccess: "rw",
      hwaccess: "none",
      fields: [
        { bits: "31:0" }
      ],
    },
    { name: "Channel_Status_c75",
      desc: "Indicates which entity has access to the Shared Memory",
      swaccess: "rw",
      hwaccess: "none",
      fields: [
        { bits: "31:2" },
        { bits: "1",
          name: "channel_error",
          desc: "Must be 0 in absence of errors"
        },
        { bits: "0",
          name: "channel_free",
          desc: "If 1 the agent own the channel, if 0 the platform own the channel"
        }
      ],
    },
    { name: "Reserved_2_c75",
      desc: "Reserved, implementation defined (32 bits over 64)",
      swaccess: "rw",
      hwaccess: "none",
      fields: [
        { bits: "31:0" }
      ],
    },
    { name: "Reserved_3_c75",
      desc: "Reserved, implementation defined (32 bits over 64)",
      swaccess: "none",
      hwaccess: "none",
      fields: [
        { bits: "31:0" }
      ],
    },
    { name: "Channel_Flags_c75",
      desc: "Defines wheter interrupts or polling is used for communication",
      swaccess: "rw",
      hwaccess: "none",
      fields: [
        { bits: "31:1" },
        { bits: "0",
          name: "intr_enable",
          desc: "If 1 interruts are used, if 0 polling is used"
        }
      ],
    },
    { name: "Length_c75",
      desc: "Lenght of payload + header",
      swaccess: "rw",
      hwaccess: "none",
      fields: [
        { bits: "31:0" }
      ],
    },
    { name: "Message_Header_c75",
      desc: "Defines which commanad the message contains",
      swaccess: "rw",
      hwaccess: "none",
      fields: [
        { bits: "31:28" },
        { bits: "27:18",
          name: "Token",
          desc: "must be same for the msg responses associated to a msg whith the same header"
        },
        { bits: "17:10",
          name: "Protocol_Id",
          desc: "Identifies to which protocol the command belongs to"
        },
        { bits: "9:8",
          name: "Message_Type",
          desc: "can be 0,1,2,3 depending on the kind of msg to be sent"
        },
        { bits: "7:0",
          name: "Message_Id",
          desc: "unique identifier for each command availabe in the protocol pointed by protocol_id"
        }
      ],
    },
    { name: "Message_Payload_1_c75",
      desc: "memory region dedicated to the parameters of the commands and their returns",
      swaccess: "rw",
      hwaccess: "none",
      fields: [
        { bits: "31:0" }
      ],
    },
    { name: "Doorbell_c75",
      desc: "Rapresents the interrupt to be raised towards the platform",
      swaccess: "rw",
      hwaccess: "hro",
      fields: [
        { bits: "31:1",
          name: "Preserve_Mask",
          desc: "These bits must be constant to 0, not used with just one platform and one agent"
        },
        { bits: "0",
          name: "intr",
          desc: "Interrupt bit"
        }
      ],
    },
    { name:  "Completion_Interrupt_c75",
      desc: "Rapresent the interrupt the platform should raise when it finishes to execute the received command",
      swaccess: "rw",
      hwaccess: "hro",
      fields: [
        { bits: "31:1",
          name: "Preserve_Mask",
          desc: "These bits must be constant to 0, not used with just one platform and one agent"
        },
        { bits: "0",
          name: "intr",
          desc: "Interrupt bit"
        }
      ],
    },
    { name: "Reserved_1_c76",
      desc: "Reserved, must be 0",
      swaccess: "rw",
      hwaccess: "none",
      fields: [
        { bits: "31:0" }
      ],
    },
    { name: "Channel_Status_c76",
      desc: "Indicates which entity has access to the Shared Memory",
      swaccess: "rw",
      hwaccess: "none",
      fields: [
        { bits: "31:2" },
        { bits: "1",
          name: "channel_error",
          desc: "Must be 0 in absence of errors"
        },
        { bits: "0",
          name: "channel_free",
          desc: "If 1 the agent own the channel, if 0 the platform own the channel"
        }
      ],
    },
    { name: "Reserved_2_c76",
      desc: "Reserved, implementation defined (32 bits over 64)",
      swaccess: "rw",
      hwaccess: "none",
      fields: [
        { bits: "31:0" }
      ],
    },
    { name: "Reserved_3_c76",
      desc: "Reserved, implementation defined (32 bits over 64)",
      swaccess: "none",
      hwaccess: "none",
      fields: [
        { bits: "31:0" }
      ],
    },
    { name: "Channel_Flags_c76",
      desc: "Defines wheter interrupts or polling is used for communication",
      swaccess: "rw",
      hwaccess: "none",
      fields: [
        { bits: "31:1" },
        { bits: "0",
          name: "intr_enable",
          desc: "If 1 interruts are used, if 0 polling is used"
        }
      ],
    },
    { name: "Length_c76",
      desc: "Lenght of payload + header",
      swaccess: "rw",
      hwaccess: "none",
      fields: [
        { bits: "31:0" }
      ],
    },
    { name: "Message_Header_c76",
      desc: "Defines which commanad the message contains",
      swaccess: "rw",
      hwaccess: "none",
      fields: [
        { bits: "31:28" },
        { bits: "27:18",
          name: "Token",
          desc: "must be same for the msg responses associated to a msg whith the same header"
        },
        { bits: "17:10",
          name: "Protocol_Id",
          desc: "Identifies to which protocol the command belongs to"
        },
        { bits: "9:8",
          name: "Message_Type",
          desc: "can be 0,1,2,3 depending on the kind of msg to be sent"
        },
        { bits: "7:0",
          name: "Message_Id",
          desc: "unique identifier for each command availabe in the protocol pointed by protocol_id"
        }
      ],
    },
    { name: "Message_Payload_1_c76",
      desc: "memory region dedicated to the parameters of the commands and their returns",
      swaccess: "rw",
      hwaccess: "none",
      fields: [
        { bits: "31:0" }
      ],
    },
    { name: "Doorbell_c76",
      desc: "Rapresents the interrupt to be raised towards the platform",
      swaccess: "rw",
      hwaccess: "hro",
      fields: [
        { bits: "31:1",
          name: "Preserve_Mask",
          desc: "These bits must be constant to 0, not used with just one platform and one agent"
        },
        { bits: "0",
          name: "intr",
          desc: "Interrupt bit"
        }
      ],
    },
    { name:  "Completion_Interrupt_c76",
      desc: "Rapresent the interrupt the platform should raise when it finishes to execute the received command",
      swaccess: "rw",
      hwaccess: "hro",
      fields: [
        { bits: "31:1",
          name: "Preserve_Mask",
          desc: "These bits must be constant to 0, not used with just one platform and one agent"
        },
        { bits: "0",
          name: "intr",
          desc: "Interrupt bit"
        }
      ],
    },
    { name: "Reserved_1_c77",
      desc: "Reserved, must be 0",
      swaccess: "rw",
      hwaccess: "none",
      fields: [
        { bits: "31:0" }
      ],
    },
    { name: "Channel_Status_c77",
      desc: "Indicates which entity has access to the Shared Memory",
      swaccess: "rw",
      hwaccess: "none",
      fields: [
        { bits: "31:2" },
        { bits: "1",
          name: "channel_error",
          desc: "Must be 0 in absence of errors"
        },
        { bits: "0",
          name: "channel_free",
          desc: "If 1 the agent own the channel, if 0 the platform own the channel"
        }
      ],
    },
    { name: "Reserved_2_c77",
      desc: "Reserved, implementation defined (32 bits over 64)",
      swaccess: "rw",
      hwaccess: "none",
      fields: [
        { bits: "31:0" }
      ],
    },
    { name: "Reserved_3_c77",
      desc: "Reserved, implementation defined (32 bits over 64)",
      swaccess: "none",
      hwaccess: "none",
      fields: [
        { bits: "31:0" }
      ],
    },
    { name: "Channel_Flags_c77",
      desc: "Defines wheter interrupts or polling is used for communication",
      swaccess: "rw",
      hwaccess: "none",
      fields: [
        { bits: "31:1" },
        { bits: "0",
          name: "intr_enable",
          desc: "If 1 interruts are used, if 0 polling is used"
        }
      ],
    },
    { name: "Length_c77",
      desc: "Lenght of payload + header",
      swaccess: "rw",
      hwaccess: "none",
      fields: [
        { bits: "31:0" }
      ],
    },
    { name: "Message_Header_c77",
      desc: "Defines which commanad the message contains",
      swaccess: "rw",
      hwaccess: "none",
      fields: [
        { bits: "31:28" },
        { bits: "27:18",
          name: "Token",
          desc: "must be same for the msg responses associated to a msg whith the same header"
        },
        { bits: "17:10",
          name: "Protocol_Id",
          desc: "Identifies to which protocol the command belongs to"
        },
        { bits: "9:8",
          name: "Message_Type",
          desc: "can be 0,1,2,3 depending on the kind of msg to be sent"
        },
        { bits: "7:0",
          name: "Message_Id",
          desc: "unique identifier for each command availabe in the protocol pointed by protocol_id"
        }
      ],
    },
    { name: "Message_Payload_1_c77",
      desc: "memory region dedicated to the parameters of the commands and their returns",
      swaccess: "rw",
      hwaccess: "none",
      fields: [
        { bits: "31:0" }
      ],
    },
    { name: "Doorbell_c77",
      desc: "Rapresents the interrupt to be raised towards the platform",
      swaccess: "rw",
      hwaccess: "hro",
      fields: [
        { bits: "31:1",
          name: "Preserve_Mask",
          desc: "These bits must be constant to 0, not used with just one platform and one agent"
        },
        { bits: "0",
          name: "intr",
          desc: "Interrupt bit"
        }
      ],
    },
    { name:  "Completion_Interrupt_c77",
      desc: "Rapresent the interrupt the platform should raise when it finishes to execute the received command",
      swaccess: "rw",
      hwaccess: "hro",
      fields: [
        { bits: "31:1",
          name: "Preserve_Mask",
          desc: "These bits must be constant to 0, not used with just one platform and one agent"
        },
        { bits: "0",
          name: "intr",
          desc: "Interrupt bit"
        }
      ],
    },
    { name: "Reserved_1_c78",
      desc: "Reserved, must be 0",
      swaccess: "rw",
      hwaccess: "none",
      fields: [
        { bits: "31:0" }
      ],
    },
    { name: "Channel_Status_c78",
      desc: "Indicates which entity has access to the Shared Memory",
      swaccess: "rw",
      hwaccess: "none",
      fields: [
        { bits: "31:2" },
        { bits: "1",
          name: "channel_error",
          desc: "Must be 0 in absence of errors"
        },
        { bits: "0",
          name: "channel_free",
          desc: "If 1 the agent own the channel, if 0 the platform own the channel"
        }
      ],
    },
    { name: "Reserved_2_c78",
      desc: "Reserved, implementation defined (32 bits over 64)",
      swaccess: "rw",
      hwaccess: "none",
      fields: [
        { bits: "31:0" }
      ],
    },
    { name: "Reserved_3_c78",
      desc: "Reserved, implementation defined (32 bits over 64)",
      swaccess: "none",
      hwaccess: "none",
      fields: [
        { bits: "31:0" }
      ],
    },
    { name: "Channel_Flags_c78",
      desc: "Defines wheter interrupts or polling is used for communication",
      swaccess: "rw",
      hwaccess: "none",
      fields: [
        { bits: "31:1" },
        { bits: "0",
          name: "intr_enable",
          desc: "If 1 interruts are used, if 0 polling is used"
        }
      ],
    },
    { name: "Length_c78",
      desc: "Lenght of payload + header",
      swaccess: "rw",
      hwaccess: "none",
      fields: [
        { bits: "31:0" }
      ],
    },
    { name: "Message_Header_c78",
      desc: "Defines which commanad the message contains",
      swaccess: "rw",
      hwaccess: "none",
      fields: [
        { bits: "31:28" },
        { bits: "27:18",
          name: "Token",
          desc: "must be same for the msg responses associated to a msg whith the same header"
        },
        { bits: "17:10",
          name: "Protocol_Id",
          desc: "Identifies to which protocol the command belongs to"
        },
        { bits: "9:8",
          name: "Message_Type",
          desc: "can be 0,1,2,3 depending on the kind of msg to be sent"
        },
        { bits: "7:0",
          name: "Message_Id",
          desc: "unique identifier for each command availabe in the protocol pointed by protocol_id"
        }
      ],
    },
    { name: "Message_Payload_1_c78",
      desc: "memory region dedicated to the parameters of the commands and their returns",
      swaccess: "rw",
      hwaccess: "none",
      fields: [
        { bits: "31:0" }
      ],
    },
    { name: "Doorbell_c78",
      desc: "Rapresents the interrupt to be raised towards the platform",
      swaccess: "rw",
      hwaccess: "hro",
      fields: [
        { bits: "31:1",
          name: "Preserve_Mask",
          desc: "These bits must be constant to 0, not used with just one platform and one agent"
        },
        { bits: "0",
          name: "intr",
          desc: "Interrupt bit"
        }
      ],
    },
    { name:  "Completion_Interrupt_c78",
      desc: "Rapresent the interrupt the platform should raise when it finishes to execute the received command",
      swaccess: "rw",
      hwaccess: "hro",
      fields: [
        { bits: "31:1",
          name: "Preserve_Mask",
          desc: "These bits must be constant to 0, not used with just one platform and one agent"
        },
        { bits: "0",
          name: "intr",
          desc: "Interrupt bit"
        }
      ],
    },
    { name: "Reserved_1_c79",
      desc: "Reserved, must be 0",
      swaccess: "rw",
      hwaccess: "none",
      fields: [
        { bits: "31:0" }
      ],
    },
    { name: "Channel_Status_c79",
      desc: "Indicates which entity has access to the Shared Memory",
      swaccess: "rw",
      hwaccess: "none",
      fields: [
        { bits: "31:2" },
        { bits: "1",
          name: "channel_error",
          desc: "Must be 0 in absence of errors"
        },
        { bits: "0",
          name: "channel_free",
          desc: "If 1 the agent own the channel, if 0 the platform own the channel"
        }
      ],
    },
    { name: "Reserved_2_c79",
      desc: "Reserved, implementation defined (32 bits over 64)",
      swaccess: "rw",
      hwaccess: "none",
      fields: [
        { bits: "31:0" }
      ],
    },
    { name: "Reserved_3_c79",
      desc: "Reserved, implementation defined (32 bits over 64)",
      swaccess: "none",
      hwaccess: "none",
      fields: [
        { bits: "31:0" }
      ],
    },
    { name: "Channel_Flags_c79",
      desc: "Defines wheter interrupts or polling is used for communication",
      swaccess: "rw",
      hwaccess: "none",
      fields: [
        { bits: "31:1" },
        { bits: "0",
          name: "intr_enable",
          desc: "If 1 interruts are used, if 0 polling is used"
        }
      ],
    },
    { name: "Length_c79",
      desc: "Lenght of payload + header",
      swaccess: "rw",
      hwaccess: "none",
      fields: [
        { bits: "31:0" }
      ],
    },
    { name: "Message_Header_c79",
      desc: "Defines which commanad the message contains",
      swaccess: "rw",
      hwaccess: "none",
      fields: [
        { bits: "31:28" },
        { bits: "27:18",
          name: "Token",
          desc: "must be same for the msg responses associated to a msg whith the same header"
        },
        { bits: "17:10",
          name: "Protocol_Id",
          desc: "Identifies to which protocol the command belongs to"
        },
        { bits: "9:8",
          name: "Message_Type",
          desc: "can be 0,1,2,3 depending on the kind of msg to be sent"
        },
        { bits: "7:0",
          name: "Message_Id",
          desc: "unique identifier for each command availabe in the protocol pointed by protocol_id"
        }
      ],
    },
    { name: "Message_Payload_1_c79",
      desc: "memory region dedicated to the parameters of the commands and their returns",
      swaccess: "rw",
      hwaccess: "none",
      fields: [
        { bits: "31:0" }
      ],
    },
    { name: "Doorbell_c79",
      desc: "Rapresents the interrupt to be raised towards the platform",
      swaccess: "rw",
      hwaccess: "hro",
      fields: [
        { bits: "31:1",
          name: "Preserve_Mask",
          desc: "These bits must be constant to 0, not used with just one platform and one agent"
        },
        { bits: "0",
          name: "intr",
          desc: "Interrupt bit"
        }
      ],
    },
    { name:  "Completion_Interrupt_c79",
      desc: "Rapresent the interrupt the platform should raise when it finishes to execute the received command",
      swaccess: "rw",
      hwaccess: "hro",
      fields: [
        { bits: "31:1",
          name: "Preserve_Mask",
          desc: "These bits must be constant to 0, not used with just one platform and one agent"
        },
        { bits: "0",
          name: "intr",
          desc: "Interrupt bit"
        }
      ],
    },
    { name: "Reserved_1_c80",
      desc: "Reserved, must be 0",
      swaccess: "rw",
      hwaccess: "none",
      fields: [
        { bits: "31:0" }
      ],
    },
    { name: "Channel_Status_c80",
      desc: "Indicates which entity has access to the Shared Memory",
      swaccess: "rw",
      hwaccess: "none",
      fields: [
        { bits: "31:2" },
        { bits: "1",
          name: "channel_error",
          desc: "Must be 0 in absence of errors"
        },
        { bits: "0",
          name: "channel_free",
          desc: "If 1 the agent own the channel, if 0 the platform own the channel"
        }
      ],
    },
    { name: "Reserved_2_c80",
      desc: "Reserved, implementation defined (32 bits over 64)",
      swaccess: "rw",
      hwaccess: "none",
      fields: [
        { bits: "31:0" }
      ],
    },
    { name: "Reserved_3_c80",
      desc: "Reserved, implementation defined (32 bits over 64)",
      swaccess: "none",
      hwaccess: "none",
      fields: [
        { bits: "31:0" }
      ],
    },
    { name: "Channel_Flags_c80",
      desc: "Defines wheter interrupts or polling is used for communication",
      swaccess: "rw",
      hwaccess: "none",
      fields: [
        { bits: "31:1" },
        { bits: "0",
          name: "intr_enable",
          desc: "If 1 interruts are used, if 0 polling is used"
        }
      ],
    },
    { name: "Length_c80",
      desc: "Lenght of payload + header",
      swaccess: "rw",
      hwaccess: "none",
      fields: [
        { bits: "31:0" }
      ],
    },
    { name: "Message_Header_c80",
      desc: "Defines which commanad the message contains",
      swaccess: "rw",
      hwaccess: "none",
      fields: [
        { bits: "31:28" },
        { bits: "27:18",
          name: "Token",
          desc: "must be same for the msg responses associated to a msg whith the same header"
        },
        { bits: "17:10",
          name: "Protocol_Id",
          desc: "Identifies to which protocol the command belongs to"
        },
        { bits: "9:8",
          name: "Message_Type",
          desc: "can be 0,1,2,3 depending on the kind of msg to be sent"
        },
        { bits: "7:0",
          name: "Message_Id",
          desc: "unique identifier for each command availabe in the protocol pointed by protocol_id"
        }
      ],
    },
    { name: "Message_Payload_1_c80",
      desc: "memory region dedicated to the parameters of the commands and their returns",
      swaccess: "rw",
      hwaccess: "none",
      fields: [
        { bits: "31:0" }
      ],
    },
    { name: "Doorbell_c80",
      desc: "Rapresents the interrupt to be raised towards the platform",
      swaccess: "rw",
      hwaccess: "hro",
      fields: [
        { bits: "31:1",
          name: "Preserve_Mask",
          desc: "These bits must be constant to 0, not used with just one platform and one agent"
        },
        { bits: "0",
          name: "intr",
          desc: "Interrupt bit"
        }
      ],
    },
    { name:  "Completion_Interrupt_c80",
      desc: "Rapresent the interrupt the platform should raise when it finishes to execute the received command",
      swaccess: "rw",
      hwaccess: "hro",
      fields: [
        { bits: "31:1",
          name: "Preserve_Mask",
          desc: "These bits must be constant to 0, not used with just one platform and one agent"
        },
        { bits: "0",
          name: "intr",
          desc: "Interrupt bit"
        }
      ],
    },
    { name: "Reserved_1_c81",
      desc: "Reserved, must be 0",
      swaccess: "rw",
      hwaccess: "none",
      fields: [
        { bits: "31:0" }
      ],
    },
    { name: "Channel_Status_c81",
      desc: "Indicates which entity has access to the Shared Memory",
      swaccess: "rw",
      hwaccess: "none",
      fields: [
        { bits: "31:2" },
        { bits: "1",
          name: "channel_error",
          desc: "Must be 0 in absence of errors"
        },
        { bits: "0",
          name: "channel_free",
          desc: "If 1 the agent own the channel, if 0 the platform own the channel"
        }
      ],
    },
    { name: "Reserved_2_c81",
      desc: "Reserved, implementation defined (32 bits over 64)",
      swaccess: "rw",
      hwaccess: "none",
      fields: [
        { bits: "31:0" }
      ],
    },
    { name: "Reserved_3_c81",
      desc: "Reserved, implementation defined (32 bits over 64)",
      swaccess: "none",
      hwaccess: "none",
      fields: [
        { bits: "31:0" }
      ],
    },
    { name: "Channel_Flags_c81",
      desc: "Defines wheter interrupts or polling is used for communication",
      swaccess: "rw",
      hwaccess: "none",
      fields: [
        { bits: "31:1" },
        { bits: "0",
          name: "intr_enable",
          desc: "If 1 interruts are used, if 0 polling is used"
        }
      ],
    },
    { name: "Length_c81",
      desc: "Lenght of payload + header",
      swaccess: "rw",
      hwaccess: "none",
      fields: [
        { bits: "31:0" }
      ],
    },
    { name: "Message_Header_c81",
      desc: "Defines which commanad the message contains",
      swaccess: "rw",
      hwaccess: "none",
      fields: [
        { bits: "31:28" },
        { bits: "27:18",
          name: "Token",
          desc: "must be same for the msg responses associated to a msg whith the same header"
        },
        { bits: "17:10",
          name: "Protocol_Id",
          desc: "Identifies to which protocol the command belongs to"
        },
        { bits: "9:8",
          name: "Message_Type",
          desc: "can be 0,1,2,3 depending on the kind of msg to be sent"
        },
        { bits: "7:0",
          name: "Message_Id",
          desc: "unique identifier for each command availabe in the protocol pointed by protocol_id"
        }
      ],
    },
    { name: "Message_Payload_1_c81",
      desc: "memory region dedicated to the parameters of the commands and their returns",
      swaccess: "rw",
      hwaccess: "none",
      fields: [
        { bits: "31:0" }
      ],
    },
    { name: "Doorbell_c81",
      desc: "Rapresents the interrupt to be raised towards the platform",
      swaccess: "rw",
      hwaccess: "hro",
      fields: [
        { bits: "31:1",
          name: "Preserve_Mask",
          desc: "These bits must be constant to 0, not used with just one platform and one agent"
        },
        { bits: "0",
          name: "intr",
          desc: "Interrupt bit"
        }
      ],
    },
    { name:  "Completion_Interrupt_c81",
      desc: "Rapresent the interrupt the platform should raise when it finishes to execute the received command",
      swaccess: "rw",
      hwaccess: "hro",
      fields: [
        { bits: "31:1",
          name: "Preserve_Mask",
          desc: "These bits must be constant to 0, not used with just one platform and one agent"
        },
        { bits: "0",
          name: "intr",
          desc: "Interrupt bit"
        }
      ],
    },
    { name: "Reserved_1_c82",
      desc: "Reserved, must be 0",
      swaccess: "rw",
      hwaccess: "none",
      fields: [
        { bits: "31:0" }
      ],
    },
    { name: "Channel_Status_c82",
      desc: "Indicates which entity has access to the Shared Memory",
      swaccess: "rw",
      hwaccess: "none",
      fields: [
        { bits: "31:2" },
        { bits: "1",
          name: "channel_error",
          desc: "Must be 0 in absence of errors"
        },
        { bits: "0",
          name: "channel_free",
          desc: "If 1 the agent own the channel, if 0 the platform own the channel"
        }
      ],
    },
    { name: "Reserved_2_c82",
      desc: "Reserved, implementation defined (32 bits over 64)",
      swaccess: "rw",
      hwaccess: "none",
      fields: [
        { bits: "31:0" }
      ],
    },
    { name: "Reserved_3_c82",
      desc: "Reserved, implementation defined (32 bits over 64)",
      swaccess: "none",
      hwaccess: "none",
      fields: [
        { bits: "31:0" }
      ],
    },
    { name: "Channel_Flags_c82",
      desc: "Defines wheter interrupts or polling is used for communication",
      swaccess: "rw",
      hwaccess: "none",
      fields: [
        { bits: "31:1" },
        { bits: "0",
          name: "intr_enable",
          desc: "If 1 interruts are used, if 0 polling is used"
        }
      ],
    },
    { name: "Length_c82",
      desc: "Lenght of payload + header",
      swaccess: "rw",
      hwaccess: "none",
      fields: [
        { bits: "31:0" }
      ],
    },
    { name: "Message_Header_c82",
      desc: "Defines which commanad the message contains",
      swaccess: "rw",
      hwaccess: "none",
      fields: [
        { bits: "31:28" },
        { bits: "27:18",
          name: "Token",
          desc: "must be same for the msg responses associated to a msg whith the same header"
        },
        { bits: "17:10",
          name: "Protocol_Id",
          desc: "Identifies to which protocol the command belongs to"
        },
        { bits: "9:8",
          name: "Message_Type",
          desc: "can be 0,1,2,3 depending on the kind of msg to be sent"
        },
        { bits: "7:0",
          name: "Message_Id",
          desc: "unique identifier for each command availabe in the protocol pointed by protocol_id"
        }
      ],
    },
    { name: "Message_Payload_1_c82",
      desc: "memory region dedicated to the parameters of the commands and their returns",
      swaccess: "rw",
      hwaccess: "none",
      fields: [
        { bits: "31:0" }
      ],
    },
    { name: "Doorbell_c82",
      desc: "Rapresents the interrupt to be raised towards the platform",
      swaccess: "rw",
      hwaccess: "hro",
      fields: [
        { bits: "31:1",
          name: "Preserve_Mask",
          desc: "These bits must be constant to 0, not used with just one platform and one agent"
        },
        { bits: "0",
          name: "intr",
          desc: "Interrupt bit"
        }
      ],
    },
    { name:  "Completion_Interrupt_c82",
      desc: "Rapresent the interrupt the platform should raise when it finishes to execute the received command",
      swaccess: "rw",
      hwaccess: "hro",
      fields: [
        { bits: "31:1",
          name: "Preserve_Mask",
          desc: "These bits must be constant to 0, not used with just one platform and one agent"
        },
        { bits: "0",
          name: "intr",
          desc: "Interrupt bit"
        }
      ],
    },
    { name: "Reserved_1_c83",
      desc: "Reserved, must be 0",
      swaccess: "rw",
      hwaccess: "none",
      fields: [
        { bits: "31:0" }
      ],
    },
    { name: "Channel_Status_c83",
      desc: "Indicates which entity has access to the Shared Memory",
      swaccess: "rw",
      hwaccess: "none",
      fields: [
        { bits: "31:2" },
        { bits: "1",
          name: "channel_error",
          desc: "Must be 0 in absence of errors"
        },
        { bits: "0",
          name: "channel_free",
          desc: "If 1 the agent own the channel, if 0 the platform own the channel"
        }
      ],
    },
    { name: "Reserved_2_c83",
      desc: "Reserved, implementation defined (32 bits over 64)",
      swaccess: "rw",
      hwaccess: "none",
      fields: [
        { bits: "31:0" }
      ],
    },
    { name: "Reserved_3_c83",
      desc: "Reserved, implementation defined (32 bits over 64)",
      swaccess: "none",
      hwaccess: "none",
      fields: [
        { bits: "31:0" }
      ],
    },
    { name: "Channel_Flags_c83",
      desc: "Defines wheter interrupts or polling is used for communication",
      swaccess: "rw",
      hwaccess: "none",
      fields: [
        { bits: "31:1" },
        { bits: "0",
          name: "intr_enable",
          desc: "If 1 interruts are used, if 0 polling is used"
        }
      ],
    },
    { name: "Length_c83",
      desc: "Lenght of payload + header",
      swaccess: "rw",
      hwaccess: "none",
      fields: [
        { bits: "31:0" }
      ],
    },
    { name: "Message_Header_c83",
      desc: "Defines which commanad the message contains",
      swaccess: "rw",
      hwaccess: "none",
      fields: [
        { bits: "31:28" },
        { bits: "27:18",
          name: "Token",
          desc: "must be same for the msg responses associated to a msg whith the same header"
        },
        { bits: "17:10",
          name: "Protocol_Id",
          desc: "Identifies to which protocol the command belongs to"
        },
        { bits: "9:8",
          name: "Message_Type",
          desc: "can be 0,1,2,3 depending on the kind of msg to be sent"
        },
        { bits: "7:0",
          name: "Message_Id",
          desc: "unique identifier for each command availabe in the protocol pointed by protocol_id"
        }
      ],
    },
    { name: "Message_Payload_1_c83",
      desc: "memory region dedicated to the parameters of the commands and their returns",
      swaccess: "rw",
      hwaccess: "none",
      fields: [
        { bits: "31:0" }
      ],
    },
    { name: "Doorbell_c83",
      desc: "Rapresents the interrupt to be raised towards the platform",
      swaccess: "rw",
      hwaccess: "hro",
      fields: [
        { bits: "31:1",
          name: "Preserve_Mask",
          desc: "These bits must be constant to 0, not used with just one platform and one agent"
        },
        { bits: "0",
          name: "intr",
          desc: "Interrupt bit"
        }
      ],
    },
    { name:  "Completion_Interrupt_c83",
      desc: "Rapresent the interrupt the platform should raise when it finishes to execute the received command",
      swaccess: "rw",
      hwaccess: "hro",
      fields: [
        { bits: "31:1",
          name: "Preserve_Mask",
          desc: "These bits must be constant to 0, not used with just one platform and one agent"
        },
        { bits: "0",
          name: "intr",
          desc: "Interrupt bit"
        }
      ],
    },
    { name: "Reserved_1_c84",
      desc: "Reserved, must be 0",
      swaccess: "rw",
      hwaccess: "none",
      fields: [
        { bits: "31:0" }
      ],
    },
    { name: "Channel_Status_c84",
      desc: "Indicates which entity has access to the Shared Memory",
      swaccess: "rw",
      hwaccess: "none",
      fields: [
        { bits: "31:2" },
        { bits: "1",
          name: "channel_error",
          desc: "Must be 0 in absence of errors"
        },
        { bits: "0",
          name: "channel_free",
          desc: "If 1 the agent own the channel, if 0 the platform own the channel"
        }
      ],
    },
    { name: "Reserved_2_c84",
      desc: "Reserved, implementation defined (32 bits over 64)",
      swaccess: "rw",
      hwaccess: "none",
      fields: [
        { bits: "31:0" }
      ],
    },
    { name: "Reserved_3_c84",
      desc: "Reserved, implementation defined (32 bits over 64)",
      swaccess: "none",
      hwaccess: "none",
      fields: [
        { bits: "31:0" }
      ],
    },
    { name: "Channel_Flags_c84",
      desc: "Defines wheter interrupts or polling is used for communication",
      swaccess: "rw",
      hwaccess: "none",
      fields: [
        { bits: "31:1" },
        { bits: "0",
          name: "intr_enable",
          desc: "If 1 interruts are used, if 0 polling is used"
        }
      ],
    },
    { name: "Length_c84",
      desc: "Lenght of payload + header",
      swaccess: "rw",
      hwaccess: "none",
      fields: [
        { bits: "31:0" }
      ],
    },
    { name: "Message_Header_c84",
      desc: "Defines which commanad the message contains",
      swaccess: "rw",
      hwaccess: "none",
      fields: [
        { bits: "31:28" },
        { bits: "27:18",
          name: "Token",
          desc: "must be same for the msg responses associated to a msg whith the same header"
        },
        { bits: "17:10",
          name: "Protocol_Id",
          desc: "Identifies to which protocol the command belongs to"
        },
        { bits: "9:8",
          name: "Message_Type",
          desc: "can be 0,1,2,3 depending on the kind of msg to be sent"
        },
        { bits: "7:0",
          name: "Message_Id",
          desc: "unique identifier for each command availabe in the protocol pointed by protocol_id"
        }
      ],
    },
    { name: "Message_Payload_1_c84",
      desc: "memory region dedicated to the parameters of the commands and their returns",
      swaccess: "rw",
      hwaccess: "none",
      fields: [
        { bits: "31:0" }
      ],
    },
    { name: "Doorbell_c84",
      desc: "Rapresents the interrupt to be raised towards the platform",
      swaccess: "rw",
      hwaccess: "hro",
      fields: [
        { bits: "31:1",
          name: "Preserve_Mask",
          desc: "These bits must be constant to 0, not used with just one platform and one agent"
        },
        { bits: "0",
          name: "intr",
          desc: "Interrupt bit"
        }
      ],
    },
    { name:  "Completion_Interrupt_c84",
      desc: "Rapresent the interrupt the platform should raise when it finishes to execute the received command",
      swaccess: "rw",
      hwaccess: "hro",
      fields: [
        { bits: "31:1",
          name: "Preserve_Mask",
          desc: "These bits must be constant to 0, not used with just one platform and one agent"
        },
        { bits: "0",
          name: "intr",
          desc: "Interrupt bit"
        }
      ],
    },
    { name: "Reserved_1_c85",
      desc: "Reserved, must be 0",
      swaccess: "rw",
      hwaccess: "none",
      fields: [
        { bits: "31:0" }
      ],
    },
    { name: "Channel_Status_c85",
      desc: "Indicates which entity has access to the Shared Memory",
      swaccess: "rw",
      hwaccess: "none",
      fields: [
        { bits: "31:2" },
        { bits: "1",
          name: "channel_error",
          desc: "Must be 0 in absence of errors"
        },
        { bits: "0",
          name: "channel_free",
          desc: "If 1 the agent own the channel, if 0 the platform own the channel"
        }
      ],
    },
    { name: "Reserved_2_c85",
      desc: "Reserved, implementation defined (32 bits over 64)",
      swaccess: "rw",
      hwaccess: "none",
      fields: [
        { bits: "31:0" }
      ],
    },
    { name: "Reserved_3_c85",
      desc: "Reserved, implementation defined (32 bits over 64)",
      swaccess: "none",
      hwaccess: "none",
      fields: [
        { bits: "31:0" }
      ],
    },
    { name: "Channel_Flags_c85",
      desc: "Defines wheter interrupts or polling is used for communication",
      swaccess: "rw",
      hwaccess: "none",
      fields: [
        { bits: "31:1" },
        { bits: "0",
          name: "intr_enable",
          desc: "If 1 interruts are used, if 0 polling is used"
        }
      ],
    },
    { name: "Length_c85",
      desc: "Lenght of payload + header",
      swaccess: "rw",
      hwaccess: "none",
      fields: [
        { bits: "31:0" }
      ],
    },
    { name: "Message_Header_c85",
      desc: "Defines which commanad the message contains",
      swaccess: "rw",
      hwaccess: "none",
      fields: [
        { bits: "31:28" },
        { bits: "27:18",
          name: "Token",
          desc: "must be same for the msg responses associated to a msg whith the same header"
        },
        { bits: "17:10",
          name: "Protocol_Id",
          desc: "Identifies to which protocol the command belongs to"
        },
        { bits: "9:8",
          name: "Message_Type",
          desc: "can be 0,1,2,3 depending on the kind of msg to be sent"
        },
        { bits: "7:0",
          name: "Message_Id",
          desc: "unique identifier for each command availabe in the protocol pointed by protocol_id"
        }
      ],
    },
    { name: "Message_Payload_1_c85",
      desc: "memory region dedicated to the parameters of the commands and their returns",
      swaccess: "rw",
      hwaccess: "none",
      fields: [
        { bits: "31:0" }
      ],
    },
    { name: "Doorbell_c85",
      desc: "Rapresents the interrupt to be raised towards the platform",
      swaccess: "rw",
      hwaccess: "hro",
      fields: [
        { bits: "31:1",
          name: "Preserve_Mask",
          desc: "These bits must be constant to 0, not used with just one platform and one agent"
        },
        { bits: "0",
          name: "intr",
          desc: "Interrupt bit"
        }
      ],
    },
    { name:  "Completion_Interrupt_c85",
      desc: "Rapresent the interrupt the platform should raise when it finishes to execute the received command",
      swaccess: "rw",
      hwaccess: "hro",
      fields: [
        { bits: "31:1",
          name: "Preserve_Mask",
          desc: "These bits must be constant to 0, not used with just one platform and one agent"
        },
        { bits: "0",
          name: "intr",
          desc: "Interrupt bit"
        }
      ],
    },
    { name: "Reserved_1_c86",
      desc: "Reserved, must be 0",
      swaccess: "rw",
      hwaccess: "none",
      fields: [
        { bits: "31:0" }
      ],
    },
    { name: "Channel_Status_c86",
      desc: "Indicates which entity has access to the Shared Memory",
      swaccess: "rw",
      hwaccess: "none",
      fields: [
        { bits: "31:2" },
        { bits: "1",
          name: "channel_error",
          desc: "Must be 0 in absence of errors"
        },
        { bits: "0",
          name: "channel_free",
          desc: "If 1 the agent own the channel, if 0 the platform own the channel"
        }
      ],
    },
    { name: "Reserved_2_c86",
      desc: "Reserved, implementation defined (32 bits over 64)",
      swaccess: "rw",
      hwaccess: "none",
      fields: [
        { bits: "31:0" }
      ],
    },
    { name: "Reserved_3_c86",
      desc: "Reserved, implementation defined (32 bits over 64)",
      swaccess: "none",
      hwaccess: "none",
      fields: [
        { bits: "31:0" }
      ],
    },
    { name: "Channel_Flags_c86",
      desc: "Defines wheter interrupts or polling is used for communication",
      swaccess: "rw",
      hwaccess: "none",
      fields: [
        { bits: "31:1" },
        { bits: "0",
          name: "intr_enable",
          desc: "If 1 interruts are used, if 0 polling is used"
        }
      ],
    },
    { name: "Length_c86",
      desc: "Lenght of payload + header",
      swaccess: "rw",
      hwaccess: "none",
      fields: [
        { bits: "31:0" }
      ],
    },
    { name: "Message_Header_c86",
      desc: "Defines which commanad the message contains",
      swaccess: "rw",
      hwaccess: "none",
      fields: [
        { bits: "31:28" },
        { bits: "27:18",
          name: "Token",
          desc: "must be same for the msg responses associated to a msg whith the same header"
        },
        { bits: "17:10",
          name: "Protocol_Id",
          desc: "Identifies to which protocol the command belongs to"
        },
        { bits: "9:8",
          name: "Message_Type",
          desc: "can be 0,1,2,3 depending on the kind of msg to be sent"
        },
        { bits: "7:0",
          name: "Message_Id",
          desc: "unique identifier for each command availabe in the protocol pointed by protocol_id"
        }
      ],
    },
    { name: "Message_Payload_1_c86",
      desc: "memory region dedicated to the parameters of the commands and their returns",
      swaccess: "rw",
      hwaccess: "none",
      fields: [
        { bits: "31:0" }
      ],
    },
    { name: "Doorbell_c86",
      desc: "Rapresents the interrupt to be raised towards the platform",
      swaccess: "rw",
      hwaccess: "hro",
      fields: [
        { bits: "31:1",
          name: "Preserve_Mask",
          desc: "These bits must be constant to 0, not used with just one platform and one agent"
        },
        { bits: "0",
          name: "intr",
          desc: "Interrupt bit"
        }
      ],
    },
    { name:  "Completion_Interrupt_c86",
      desc: "Rapresent the interrupt the platform should raise when it finishes to execute the received command",
      swaccess: "rw",
      hwaccess: "hro",
      fields: [
        { bits: "31:1",
          name: "Preserve_Mask",
          desc: "These bits must be constant to 0, not used with just one platform and one agent"
        },
        { bits: "0",
          name: "intr",
          desc: "Interrupt bit"
        }
      ],
    },
    { name: "Reserved_1_c87",
      desc: "Reserved, must be 0",
      swaccess: "rw",
      hwaccess: "none",
      fields: [
        { bits: "31:0" }
      ],
    },
    { name: "Channel_Status_c87",
      desc: "Indicates which entity has access to the Shared Memory",
      swaccess: "rw",
      hwaccess: "none",
      fields: [
        { bits: "31:2" },
        { bits: "1",
          name: "channel_error",
          desc: "Must be 0 in absence of errors"
        },
        { bits: "0",
          name: "channel_free",
          desc: "If 1 the agent own the channel, if 0 the platform own the channel"
        }
      ],
    },
    { name: "Reserved_2_c87",
      desc: "Reserved, implementation defined (32 bits over 64)",
      swaccess: "rw",
      hwaccess: "none",
      fields: [
        { bits: "31:0" }
      ],
    },
    { name: "Reserved_3_c87",
      desc: "Reserved, implementation defined (32 bits over 64)",
      swaccess: "none",
      hwaccess: "none",
      fields: [
        { bits: "31:0" }
      ],
    },
    { name: "Channel_Flags_c87",
      desc: "Defines wheter interrupts or polling is used for communication",
      swaccess: "rw",
      hwaccess: "none",
      fields: [
        { bits: "31:1" },
        { bits: "0",
          name: "intr_enable",
          desc: "If 1 interruts are used, if 0 polling is used"
        }
      ],
    },
    { name: "Length_c87",
      desc: "Lenght of payload + header",
      swaccess: "rw",
      hwaccess: "none",
      fields: [
        { bits: "31:0" }
      ],
    },
    { name: "Message_Header_c87",
      desc: "Defines which commanad the message contains",
      swaccess: "rw",
      hwaccess: "none",
      fields: [
        { bits: "31:28" },
        { bits: "27:18",
          name: "Token",
          desc: "must be same for the msg responses associated to a msg whith the same header"
        },
        { bits: "17:10",
          name: "Protocol_Id",
          desc: "Identifies to which protocol the command belongs to"
        },
        { bits: "9:8",
          name: "Message_Type",
          desc: "can be 0,1,2,3 depending on the kind of msg to be sent"
        },
        { bits: "7:0",
          name: "Message_Id",
          desc: "unique identifier for each command availabe in the protocol pointed by protocol_id"
        }
      ],
    },
    { name: "Message_Payload_1_c87",
      desc: "memory region dedicated to the parameters of the commands and their returns",
      swaccess: "rw",
      hwaccess: "none",
      fields: [
        { bits: "31:0" }
      ],
    },
    { name: "Doorbell_c87",
      desc: "Rapresents the interrupt to be raised towards the platform",
      swaccess: "rw",
      hwaccess: "hro",
      fields: [
        { bits: "31:1",
          name: "Preserve_Mask",
          desc: "These bits must be constant to 0, not used with just one platform and one agent"
        },
        { bits: "0",
          name: "intr",
          desc: "Interrupt bit"
        }
      ],
    },
    { name:  "Completion_Interrupt_c87",
      desc: "Rapresent the interrupt the platform should raise when it finishes to execute the received command",
      swaccess: "rw",
      hwaccess: "hro",
      fields: [
        { bits: "31:1",
          name: "Preserve_Mask",
          desc: "These bits must be constant to 0, not used with just one platform and one agent"
        },
        { bits: "0",
          name: "intr",
          desc: "Interrupt bit"
        }
      ],
    },
    { name: "Reserved_1_c88",
      desc: "Reserved, must be 0",
      swaccess: "rw",
      hwaccess: "none",
      fields: [
        { bits: "31:0" }
      ],
    },
    { name: "Channel_Status_c88",
      desc: "Indicates which entity has access to the Shared Memory",
      swaccess: "rw",
      hwaccess: "none",
      fields: [
        { bits: "31:2" },
        { bits: "1",
          name: "channel_error",
          desc: "Must be 0 in absence of errors"
        },
        { bits: "0",
          name: "channel_free",
          desc: "If 1 the agent own the channel, if 0 the platform own the channel"
        }
      ],
    },
    { name: "Reserved_2_c88",
      desc: "Reserved, implementation defined (32 bits over 64)",
      swaccess: "rw",
      hwaccess: "none",
      fields: [
        { bits: "31:0" }
      ],
    },
    { name: "Reserved_3_c88",
      desc: "Reserved, implementation defined (32 bits over 64)",
      swaccess: "none",
      hwaccess: "none",
      fields: [
        { bits: "31:0" }
      ],
    },
    { name: "Channel_Flags_c88",
      desc: "Defines wheter interrupts or polling is used for communication",
      swaccess: "rw",
      hwaccess: "none",
      fields: [
        { bits: "31:1" },
        { bits: "0",
          name: "intr_enable",
          desc: "If 1 interruts are used, if 0 polling is used"
        }
      ],
    },
    { name: "Length_c88",
      desc: "Lenght of payload + header",
      swaccess: "rw",
      hwaccess: "none",
      fields: [
        { bits: "31:0" }
      ],
    },
    { name: "Message_Header_c88",
      desc: "Defines which commanad the message contains",
      swaccess: "rw",
      hwaccess: "none",
      fields: [
        { bits: "31:28" },
        { bits: "27:18",
          name: "Token",
          desc: "must be same for the msg responses associated to a msg whith the same header"
        },
        { bits: "17:10",
          name: "Protocol_Id",
          desc: "Identifies to which protocol the command belongs to"
        },
        { bits: "9:8",
          name: "Message_Type",
          desc: "can be 0,1,2,3 depending on the kind of msg to be sent"
        },
        { bits: "7:0",
          name: "Message_Id",
          desc: "unique identifier for each command availabe in the protocol pointed by protocol_id"
        }
      ],
    },
    { name: "Message_Payload_1_c88",
      desc: "memory region dedicated to the parameters of the commands and their returns",
      swaccess: "rw",
      hwaccess: "none",
      fields: [
        { bits: "31:0" }
      ],
    },
    { name: "Doorbell_c88",
      desc: "Rapresents the interrupt to be raised towards the platform",
      swaccess: "rw",
      hwaccess: "hro",
      fields: [
        { bits: "31:1",
          name: "Preserve_Mask",
          desc: "These bits must be constant to 0, not used with just one platform and one agent"
        },
        { bits: "0",
          name: "intr",
          desc: "Interrupt bit"
        }
      ],
    },
    { name:  "Completion_Interrupt_c88",
      desc: "Rapresent the interrupt the platform should raise when it finishes to execute the received command",
      swaccess: "rw",
      hwaccess: "hro",
      fields: [
        { bits: "31:1",
          name: "Preserve_Mask",
          desc: "These bits must be constant to 0, not used with just one platform and one agent"
        },
        { bits: "0",
          name: "intr",
          desc: "Interrupt bit"
        }
      ],
    },
    { name: "Reserved_1_c89",
      desc: "Reserved, must be 0",
      swaccess: "rw",
      hwaccess: "none",
      fields: [
        { bits: "31:0" }
      ],
    },
    { name: "Channel_Status_c89",
      desc: "Indicates which entity has access to the Shared Memory",
      swaccess: "rw",
      hwaccess: "none",
      fields: [
        { bits: "31:2" },
        { bits: "1",
          name: "channel_error",
          desc: "Must be 0 in absence of errors"
        },
        { bits: "0",
          name: "channel_free",
          desc: "If 1 the agent own the channel, if 0 the platform own the channel"
        }
      ],
    },
    { name: "Reserved_2_c89",
      desc: "Reserved, implementation defined (32 bits over 64)",
      swaccess: "rw",
      hwaccess: "none",
      fields: [
        { bits: "31:0" }
      ],
    },
    { name: "Reserved_3_c89",
      desc: "Reserved, implementation defined (32 bits over 64)",
      swaccess: "none",
      hwaccess: "none",
      fields: [
        { bits: "31:0" }
      ],
    },
    { name: "Channel_Flags_c89",
      desc: "Defines wheter interrupts or polling is used for communication",
      swaccess: "rw",
      hwaccess: "none",
      fields: [
        { bits: "31:1" },
        { bits: "0",
          name: "intr_enable",
          desc: "If 1 interruts are used, if 0 polling is used"
        }
      ],
    },
    { name: "Length_c89",
      desc: "Lenght of payload + header",
      swaccess: "rw",
      hwaccess: "none",
      fields: [
        { bits: "31:0" }
      ],
    },
    { name: "Message_Header_c89",
      desc: "Defines which commanad the message contains",
      swaccess: "rw",
      hwaccess: "none",
      fields: [
        { bits: "31:28" },
        { bits: "27:18",
          name: "Token",
          desc: "must be same for the msg responses associated to a msg whith the same header"
        },
        { bits: "17:10",
          name: "Protocol_Id",
          desc: "Identifies to which protocol the command belongs to"
        },
        { bits: "9:8",
          name: "Message_Type",
          desc: "can be 0,1,2,3 depending on the kind of msg to be sent"
        },
        { bits: "7:0",
          name: "Message_Id",
          desc: "unique identifier for each command availabe in the protocol pointed by protocol_id"
        }
      ],
    },
    { name: "Message_Payload_1_c89",
      desc: "memory region dedicated to the parameters of the commands and their returns",
      swaccess: "rw",
      hwaccess: "none",
      fields: [
        { bits: "31:0" }
      ],
    },
    { name: "Doorbell_c89",
      desc: "Rapresents the interrupt to be raised towards the platform",
      swaccess: "rw",
      hwaccess: "hro",
      fields: [
        { bits: "31:1",
          name: "Preserve_Mask",
          desc: "These bits must be constant to 0, not used with just one platform and one agent"
        },
        { bits: "0",
          name: "intr",
          desc: "Interrupt bit"
        }
      ],
    },
    { name:  "Completion_Interrupt_c89",
      desc: "Rapresent the interrupt the platform should raise when it finishes to execute the received command",
      swaccess: "rw",
      hwaccess: "hro",
      fields: [
        { bits: "31:1",
          name: "Preserve_Mask",
          desc: "These bits must be constant to 0, not used with just one platform and one agent"
        },
        { bits: "0",
          name: "intr",
          desc: "Interrupt bit"
        }
      ],
    },
    { name: "Reserved_1_c90",
      desc: "Reserved, must be 0",
      swaccess: "rw",
      hwaccess: "none",
      fields: [
        { bits: "31:0" }
      ],
    },
    { name: "Channel_Status_c90",
      desc: "Indicates which entity has access to the Shared Memory",
      swaccess: "rw",
      hwaccess: "none",
      fields: [
        { bits: "31:2" },
        { bits: "1",
          name: "channel_error",
          desc: "Must be 0 in absence of errors"
        },
        { bits: "0",
          name: "channel_free",
          desc: "If 1 the agent own the channel, if 0 the platform own the channel"
        }
      ],
    },
    { name: "Reserved_2_c90",
      desc: "Reserved, implementation defined (32 bits over 64)",
      swaccess: "rw",
      hwaccess: "none",
      fields: [
        { bits: "31:0" }
      ],
    },
    { name: "Reserved_3_c90",
      desc: "Reserved, implementation defined (32 bits over 64)",
      swaccess: "none",
      hwaccess: "none",
      fields: [
        { bits: "31:0" }
      ],
    },
    { name: "Channel_Flags_c90",
      desc: "Defines wheter interrupts or polling is used for communication",
      swaccess: "rw",
      hwaccess: "none",
      fields: [
        { bits: "31:1" },
        { bits: "0",
          name: "intr_enable",
          desc: "If 1 interruts are used, if 0 polling is used"
        }
      ],
    },
    { name: "Length_c90",
      desc: "Lenght of payload + header",
      swaccess: "rw",
      hwaccess: "none",
      fields: [
        { bits: "31:0" }
      ],
    },
    { name: "Message_Header_c90",
      desc: "Defines which commanad the message contains",
      swaccess: "rw",
      hwaccess: "none",
      fields: [
        { bits: "31:28" },
        { bits: "27:18",
          name: "Token",
          desc: "must be same for the msg responses associated to a msg whith the same header"
        },
        { bits: "17:10",
          name: "Protocol_Id",
          desc: "Identifies to which protocol the command belongs to"
        },
        { bits: "9:8",
          name: "Message_Type",
          desc: "can be 0,1,2,3 depending on the kind of msg to be sent"
        },
        { bits: "7:0",
          name: "Message_Id",
          desc: "unique identifier for each command availabe in the protocol pointed by protocol_id"
        }
      ],
    },
    { name: "Message_Payload_1_c90",
      desc: "memory region dedicated to the parameters of the commands and their returns",
      swaccess: "rw",
      hwaccess: "none",
      fields: [
        { bits: "31:0" }
      ],
    },
    { name: "Doorbell_c90",
      desc: "Rapresents the interrupt to be raised towards the platform",
      swaccess: "rw",
      hwaccess: "hro",
      fields: [
        { bits: "31:1",
          name: "Preserve_Mask",
          desc: "These bits must be constant to 0, not used with just one platform and one agent"
        },
        { bits: "0",
          name: "intr",
          desc: "Interrupt bit"
        }
      ],
    },
    { name:  "Completion_Interrupt_c90",
      desc: "Rapresent the interrupt the platform should raise when it finishes to execute the received command",
      swaccess: "rw",
      hwaccess: "hro",
      fields: [
        { bits: "31:1",
          name: "Preserve_Mask",
          desc: "These bits must be constant to 0, not used with just one platform and one agent"
        },
        { bits: "0",
          name: "intr",
          desc: "Interrupt bit"
        }
      ],
    },
    { name: "Reserved_1_c91",
      desc: "Reserved, must be 0",
      swaccess: "rw",
      hwaccess: "none",
      fields: [
        { bits: "31:0" }
      ],
    },
    { name: "Channel_Status_c91",
      desc: "Indicates which entity has access to the Shared Memory",
      swaccess: "rw",
      hwaccess: "none",
      fields: [
        { bits: "31:2" },
        { bits: "1",
          name: "channel_error",
          desc: "Must be 0 in absence of errors"
        },
        { bits: "0",
          name: "channel_free",
          desc: "If 1 the agent own the channel, if 0 the platform own the channel"
        }
      ],
    },
    { name: "Reserved_2_c91",
      desc: "Reserved, implementation defined (32 bits over 64)",
      swaccess: "rw",
      hwaccess: "none",
      fields: [
        { bits: "31:0" }
      ],
    },
    { name: "Reserved_3_c91",
      desc: "Reserved, implementation defined (32 bits over 64)",
      swaccess: "none",
      hwaccess: "none",
      fields: [
        { bits: "31:0" }
      ],
    },
    { name: "Channel_Flags_c91",
      desc: "Defines wheter interrupts or polling is used for communication",
      swaccess: "rw",
      hwaccess: "none",
      fields: [
        { bits: "31:1" },
        { bits: "0",
          name: "intr_enable",
          desc: "If 1 interruts are used, if 0 polling is used"
        }
      ],
    },
    { name: "Length_c91",
      desc: "Lenght of payload + header",
      swaccess: "rw",
      hwaccess: "none",
      fields: [
        { bits: "31:0" }
      ],
    },
    { name: "Message_Header_c91",
      desc: "Defines which commanad the message contains",
      swaccess: "rw",
      hwaccess: "none",
      fields: [
        { bits: "31:28" },
        { bits: "27:18",
          name: "Token",
          desc: "must be same for the msg responses associated to a msg whith the same header"
        },
        { bits: "17:10",
          name: "Protocol_Id",
          desc: "Identifies to which protocol the command belongs to"
        },
        { bits: "9:8",
          name: "Message_Type",
          desc: "can be 0,1,2,3 depending on the kind of msg to be sent"
        },
        { bits: "7:0",
          name: "Message_Id",
          desc: "unique identifier for each command availabe in the protocol pointed by protocol_id"
        }
      ],
    },
    { name: "Message_Payload_1_c91",
      desc: "memory region dedicated to the parameters of the commands and their returns",
      swaccess: "rw",
      hwaccess: "none",
      fields: [
        { bits: "31:0" }
      ],
    },
    { name: "Doorbell_c91",
      desc: "Rapresents the interrupt to be raised towards the platform",
      swaccess: "rw",
      hwaccess: "hro",
      fields: [
        { bits: "31:1",
          name: "Preserve_Mask",
          desc: "These bits must be constant to 0, not used with just one platform and one agent"
        },
        { bits: "0",
          name: "intr",
          desc: "Interrupt bit"
        }
      ],
    },
    { name:  "Completion_Interrupt_c91",
      desc: "Rapresent the interrupt the platform should raise when it finishes to execute the received command",
      swaccess: "rw",
      hwaccess: "hro",
      fields: [
        { bits: "31:1",
          name: "Preserve_Mask",
          desc: "These bits must be constant to 0, not used with just one platform and one agent"
        },
        { bits: "0",
          name: "intr",
          desc: "Interrupt bit"
        }
      ],
    },
    { name: "Reserved_1_c92",
      desc: "Reserved, must be 0",
      swaccess: "rw",
      hwaccess: "none",
      fields: [
        { bits: "31:0" }
      ],
    },
    { name: "Channel_Status_c92",
      desc: "Indicates which entity has access to the Shared Memory",
      swaccess: "rw",
      hwaccess: "none",
      fields: [
        { bits: "31:2" },
        { bits: "1",
          name: "channel_error",
          desc: "Must be 0 in absence of errors"
        },
        { bits: "0",
          name: "channel_free",
          desc: "If 1 the agent own the channel, if 0 the platform own the channel"
        }
      ],
    },
    { name: "Reserved_2_c92",
      desc: "Reserved, implementation defined (32 bits over 64)",
      swaccess: "rw",
      hwaccess: "none",
      fields: [
        { bits: "31:0" }
      ],
    },
    { name: "Reserved_3_c92",
      desc: "Reserved, implementation defined (32 bits over 64)",
      swaccess: "none",
      hwaccess: "none",
      fields: [
        { bits: "31:0" }
      ],
    },
    { name: "Channel_Flags_c92",
      desc: "Defines wheter interrupts or polling is used for communication",
      swaccess: "rw",
      hwaccess: "none",
      fields: [
        { bits: "31:1" },
        { bits: "0",
          name: "intr_enable",
          desc: "If 1 interruts are used, if 0 polling is used"
        }
      ],
    },
    { name: "Length_c92",
      desc: "Lenght of payload + header",
      swaccess: "rw",
      hwaccess: "none",
      fields: [
        { bits: "31:0" }
      ],
    },
    { name: "Message_Header_c92",
      desc: "Defines which commanad the message contains",
      swaccess: "rw",
      hwaccess: "none",
      fields: [
        { bits: "31:28" },
        { bits: "27:18",
          name: "Token",
          desc: "must be same for the msg responses associated to a msg whith the same header"
        },
        { bits: "17:10",
          name: "Protocol_Id",
          desc: "Identifies to which protocol the command belongs to"
        },
        { bits: "9:8",
          name: "Message_Type",
          desc: "can be 0,1,2,3 depending on the kind of msg to be sent"
        },
        { bits: "7:0",
          name: "Message_Id",
          desc: "unique identifier for each command availabe in the protocol pointed by protocol_id"
        }
      ],
    },
    { name: "Message_Payload_1_c92",
      desc: "memory region dedicated to the parameters of the commands and their returns",
      swaccess: "rw",
      hwaccess: "none",
      fields: [
        { bits: "31:0" }
      ],
    },
    { name: "Doorbell_c92",
      desc: "Rapresents the interrupt to be raised towards the platform",
      swaccess: "rw",
      hwaccess: "hro",
      fields: [
        { bits: "31:1",
          name: "Preserve_Mask",
          desc: "These bits must be constant to 0, not used with just one platform and one agent"
        },
        { bits: "0",
          name: "intr",
          desc: "Interrupt bit"
        }
      ],
    },
    { name:  "Completion_Interrupt_c92",
      desc: "Rapresent the interrupt the platform should raise when it finishes to execute the received command",
      swaccess: "rw",
      hwaccess: "hro",
      fields: [
        { bits: "31:1",
          name: "Preserve_Mask",
          desc: "These bits must be constant to 0, not used with just one platform and one agent"
        },
        { bits: "0",
          name: "intr",
          desc: "Interrupt bit"
        }
      ],
    },
    { name: "Reserved_1_c93",
      desc: "Reserved, must be 0",
      swaccess: "rw",
      hwaccess: "none",
      fields: [
        { bits: "31:0" }
      ],
    },
    { name: "Channel_Status_c93",
      desc: "Indicates which entity has access to the Shared Memory",
      swaccess: "rw",
      hwaccess: "none",
      fields: [
        { bits: "31:2" },
        { bits: "1",
          name: "channel_error",
          desc: "Must be 0 in absence of errors"
        },
        { bits: "0",
          name: "channel_free",
          desc: "If 1 the agent own the channel, if 0 the platform own the channel"
        }
      ],
    },
    { name: "Reserved_2_c93",
      desc: "Reserved, implementation defined (32 bits over 64)",
      swaccess: "rw",
      hwaccess: "none",
      fields: [
        { bits: "31:0" }
      ],
    },
    { name: "Reserved_3_c93",
      desc: "Reserved, implementation defined (32 bits over 64)",
      swaccess: "none",
      hwaccess: "none",
      fields: [
        { bits: "31:0" }
      ],
    },
    { name: "Channel_Flags_c93",
      desc: "Defines wheter interrupts or polling is used for communication",
      swaccess: "rw",
      hwaccess: "none",
      fields: [
        { bits: "31:1" },
        { bits: "0",
          name: "intr_enable",
          desc: "If 1 interruts are used, if 0 polling is used"
        }
      ],
    },
    { name: "Length_c93",
      desc: "Lenght of payload + header",
      swaccess: "rw",
      hwaccess: "none",
      fields: [
        { bits: "31:0" }
      ],
    },
    { name: "Message_Header_c93",
      desc: "Defines which commanad the message contains",
      swaccess: "rw",
      hwaccess: "none",
      fields: [
        { bits: "31:28" },
        { bits: "27:18",
          name: "Token",
          desc: "must be same for the msg responses associated to a msg whith the same header"
        },
        { bits: "17:10",
          name: "Protocol_Id",
          desc: "Identifies to which protocol the command belongs to"
        },
        { bits: "9:8",
          name: "Message_Type",
          desc: "can be 0,1,2,3 depending on the kind of msg to be sent"
        },
        { bits: "7:0",
          name: "Message_Id",
          desc: "unique identifier for each command availabe in the protocol pointed by protocol_id"
        }
      ],
    },
    { name: "Message_Payload_1_c93",
      desc: "memory region dedicated to the parameters of the commands and their returns",
      swaccess: "rw",
      hwaccess: "none",
      fields: [
        { bits: "31:0" }
      ],
    },
    { name: "Doorbell_c93",
      desc: "Rapresents the interrupt to be raised towards the platform",
      swaccess: "rw",
      hwaccess: "hro",
      fields: [
        { bits: "31:1",
          name: "Preserve_Mask",
          desc: "These bits must be constant to 0, not used with just one platform and one agent"
        },
        { bits: "0",
          name: "intr",
          desc: "Interrupt bit"
        }
      ],
    },
    { name:  "Completion_Interrupt_c93",
      desc: "Rapresent the interrupt the platform should raise when it finishes to execute the received command",
      swaccess: "rw",
      hwaccess: "hro",
      fields: [
        { bits: "31:1",
          name: "Preserve_Mask",
          desc: "These bits must be constant to 0, not used with just one platform and one agent"
        },
        { bits: "0",
          name: "intr",
          desc: "Interrupt bit"
        }
      ],
    },
    { name: "Reserved_1_c94",
      desc: "Reserved, must be 0",
      swaccess: "rw",
      hwaccess: "none",
      fields: [
        { bits: "31:0" }
      ],
    },
    { name: "Channel_Status_c94",
      desc: "Indicates which entity has access to the Shared Memory",
      swaccess: "rw",
      hwaccess: "none",
      fields: [
        { bits: "31:2" },
        { bits: "1",
          name: "channel_error",
          desc: "Must be 0 in absence of errors"
        },
        { bits: "0",
          name: "channel_free",
          desc: "If 1 the agent own the channel, if 0 the platform own the channel"
        }
      ],
    },
    { name: "Reserved_2_c94",
      desc: "Reserved, implementation defined (32 bits over 64)",
      swaccess: "rw",
      hwaccess: "none",
      fields: [
        { bits: "31:0" }
      ],
    },
    { name: "Reserved_3_c94",
      desc: "Reserved, implementation defined (32 bits over 64)",
      swaccess: "none",
      hwaccess: "none",
      fields: [
        { bits: "31:0" }
      ],
    },
    { name: "Channel_Flags_c94",
      desc: "Defines wheter interrupts or polling is used for communication",
      swaccess: "rw",
      hwaccess: "none",
      fields: [
        { bits: "31:1" },
        { bits: "0",
          name: "intr_enable",
          desc: "If 1 interruts are used, if 0 polling is used"
        }
      ],
    },
    { name: "Length_c94",
      desc: "Lenght of payload + header",
      swaccess: "rw",
      hwaccess: "none",
      fields: [
        { bits: "31:0" }
      ],
    },
    { name: "Message_Header_c94",
      desc: "Defines which commanad the message contains",
      swaccess: "rw",
      hwaccess: "none",
      fields: [
        { bits: "31:28" },
        { bits: "27:18",
          name: "Token",
          desc: "must be same for the msg responses associated to a msg whith the same header"
        },
        { bits: "17:10",
          name: "Protocol_Id",
          desc: "Identifies to which protocol the command belongs to"
        },
        { bits: "9:8",
          name: "Message_Type",
          desc: "can be 0,1,2,3 depending on the kind of msg to be sent"
        },
        { bits: "7:0",
          name: "Message_Id",
          desc: "unique identifier for each command availabe in the protocol pointed by protocol_id"
        }
      ],
    },
    { name: "Message_Payload_1_c94",
      desc: "memory region dedicated to the parameters of the commands and their returns",
      swaccess: "rw",
      hwaccess: "none",
      fields: [
        { bits: "31:0" }
      ],
    },
    { name: "Doorbell_c94",
      desc: "Rapresents the interrupt to be raised towards the platform",
      swaccess: "rw",
      hwaccess: "hro",
      fields: [
        { bits: "31:1",
          name: "Preserve_Mask",
          desc: "These bits must be constant to 0, not used with just one platform and one agent"
        },
        { bits: "0",
          name: "intr",
          desc: "Interrupt bit"
        }
      ],
    },
    { name:  "Completion_Interrupt_c94",
      desc: "Rapresent the interrupt the platform should raise when it finishes to execute the received command",
      swaccess: "rw",
      hwaccess: "hro",
      fields: [
        { bits: "31:1",
          name: "Preserve_Mask",
          desc: "These bits must be constant to 0, not used with just one platform and one agent"
        },
        { bits: "0",
          name: "intr",
          desc: "Interrupt bit"
        }
      ],
    },
    { name: "Reserved_1_c95",
      desc: "Reserved, must be 0",
      swaccess: "rw",
      hwaccess: "none",
      fields: [
        { bits: "31:0" }
      ],
    },
    { name: "Channel_Status_c95",
      desc: "Indicates which entity has access to the Shared Memory",
      swaccess: "rw",
      hwaccess: "none",
      fields: [
        { bits: "31:2" },
        { bits: "1",
          name: "channel_error",
          desc: "Must be 0 in absence of errors"
        },
        { bits: "0",
          name: "channel_free",
          desc: "If 1 the agent own the channel, if 0 the platform own the channel"
        }
      ],
    },
    { name: "Reserved_2_c95",
      desc: "Reserved, implementation defined (32 bits over 64)",
      swaccess: "rw",
      hwaccess: "none",
      fields: [
        { bits: "31:0" }
      ],
    },
    { name: "Reserved_3_c95",
      desc: "Reserved, implementation defined (32 bits over 64)",
      swaccess: "none",
      hwaccess: "none",
      fields: [
        { bits: "31:0" }
      ],
    },
    { name: "Channel_Flags_c95",
      desc: "Defines wheter interrupts or polling is used for communication",
      swaccess: "rw",
      hwaccess: "none",
      fields: [
        { bits: "31:1" },
        { bits: "0",
          name: "intr_enable",
          desc: "If 1 interruts are used, if 0 polling is used"
        }
      ],
    },
    { name: "Length_c95",
      desc: "Lenght of payload + header",
      swaccess: "rw",
      hwaccess: "none",
      fields: [
        { bits: "31:0" }
      ],
    },
    { name: "Message_Header_c95",
      desc: "Defines which commanad the message contains",
      swaccess: "rw",
      hwaccess: "none",
      fields: [
        { bits: "31:28" },
        { bits: "27:18",
          name: "Token",
          desc: "must be same for the msg responses associated to a msg whith the same header"
        },
        { bits: "17:10",
          name: "Protocol_Id",
          desc: "Identifies to which protocol the command belongs to"
        },
        { bits: "9:8",
          name: "Message_Type",
          desc: "can be 0,1,2,3 depending on the kind of msg to be sent"
        },
        { bits: "7:0",
          name: "Message_Id",
          desc: "unique identifier for each command availabe in the protocol pointed by protocol_id"
        }
      ],
    },
    { name: "Message_Payload_1_c95",
      desc: "memory region dedicated to the parameters of the commands and their returns",
      swaccess: "rw",
      hwaccess: "none",
      fields: [
        { bits: "31:0" }
      ],
    },
    { name: "Doorbell_c95",
      desc: "Rapresents the interrupt to be raised towards the platform",
      swaccess: "rw",
      hwaccess: "hro",
      fields: [
        { bits: "31:1",
          name: "Preserve_Mask",
          desc: "These bits must be constant to 0, not used with just one platform and one agent"
        },
        { bits: "0",
          name: "intr",
          desc: "Interrupt bit"
        }
      ],
    },
    { name:  "Completion_Interrupt_c95",
      desc: "Rapresent the interrupt the platform should raise when it finishes to execute the received command",
      swaccess: "rw",
      hwaccess: "hro",
      fields: [
        { bits: "31:1",
          name: "Preserve_Mask",
          desc: "These bits must be constant to 0, not used with just one platform and one agent"
        },
        { bits: "0",
          name: "intr",
          desc: "Interrupt bit"
        }
      ],
    },
    { name: "Reserved_1_c96",
      desc: "Reserved, must be 0",
      swaccess: "rw",
      hwaccess: "none",
      fields: [
        { bits: "31:0" }
      ],
    },
    { name: "Channel_Status_c96",
      desc: "Indicates which entity has access to the Shared Memory",
      swaccess: "rw",
      hwaccess: "none",
      fields: [
        { bits: "31:2" },
        { bits: "1",
          name: "channel_error",
          desc: "Must be 0 in absence of errors"
        },
        { bits: "0",
          name: "channel_free",
          desc: "If 1 the agent own the channel, if 0 the platform own the channel"
        }
      ],
    },
    { name: "Reserved_2_c96",
      desc: "Reserved, implementation defined (32 bits over 64)",
      swaccess: "rw",
      hwaccess: "none",
      fields: [
        { bits: "31:0" }
      ],
    },
    { name: "Reserved_3_c96",
      desc: "Reserved, implementation defined (32 bits over 64)",
      swaccess: "none",
      hwaccess: "none",
      fields: [
        { bits: "31:0" }
      ],
    },
    { name: "Channel_Flags_c96",
      desc: "Defines wheter interrupts or polling is used for communication",
      swaccess: "rw",
      hwaccess: "none",
      fields: [
        { bits: "31:1" },
        { bits: "0",
          name: "intr_enable",
          desc: "If 1 interruts are used, if 0 polling is used"
        }
      ],
    },
    { name: "Length_c96",
      desc: "Lenght of payload + header",
      swaccess: "rw",
      hwaccess: "none",
      fields: [
        { bits: "31:0" }
      ],
    },
    { name: "Message_Header_c96",
      desc: "Defines which commanad the message contains",
      swaccess: "rw",
      hwaccess: "none",
      fields: [
        { bits: "31:28" },
        { bits: "27:18",
          name: "Token",
          desc: "must be same for the msg responses associated to a msg whith the same header"
        },
        { bits: "17:10",
          name: "Protocol_Id",
          desc: "Identifies to which protocol the command belongs to"
        },
        { bits: "9:8",
          name: "Message_Type",
          desc: "can be 0,1,2,3 depending on the kind of msg to be sent"
        },
        { bits: "7:0",
          name: "Message_Id",
          desc: "unique identifier for each command availabe in the protocol pointed by protocol_id"
        }
      ],
    },
    { name: "Message_Payload_1_c96",
      desc: "memory region dedicated to the parameters of the commands and their returns",
      swaccess: "rw",
      hwaccess: "none",
      fields: [
        { bits: "31:0" }
      ],
    },
    { name: "Doorbell_c96",
      desc: "Rapresents the interrupt to be raised towards the platform",
      swaccess: "rw",
      hwaccess: "hro",
      fields: [
        { bits: "31:1",
          name: "Preserve_Mask",
          desc: "These bits must be constant to 0, not used with just one platform and one agent"
        },
        { bits: "0",
          name: "intr",
          desc: "Interrupt bit"
        }
      ],
    },
    { name:  "Completion_Interrupt_c96",
      desc: "Rapresent the interrupt the platform should raise when it finishes to execute the received command",
      swaccess: "rw",
      hwaccess: "hro",
      fields: [
        { bits: "31:1",
          name: "Preserve_Mask",
          desc: "These bits must be constant to 0, not used with just one platform and one agent"
        },
        { bits: "0",
          name: "intr",
          desc: "Interrupt bit"
        }
      ],
    },
    { name: "Reserved_1_c97",
      desc: "Reserved, must be 0",
      swaccess: "rw",
      hwaccess: "none",
      fields: [
        { bits: "31:0" }
      ],
    },
    { name: "Channel_Status_c97",
      desc: "Indicates which entity has access to the Shared Memory",
      swaccess: "rw",
      hwaccess: "none",
      fields: [
        { bits: "31:2" },
        { bits: "1",
          name: "channel_error",
          desc: "Must be 0 in absence of errors"
        },
        { bits: "0",
          name: "channel_free",
          desc: "If 1 the agent own the channel, if 0 the platform own the channel"
        }
      ],
    },
    { name: "Reserved_2_c97",
      desc: "Reserved, implementation defined (32 bits over 64)",
      swaccess: "rw",
      hwaccess: "none",
      fields: [
        { bits: "31:0" }
      ],
    },
    { name: "Reserved_3_c97",
      desc: "Reserved, implementation defined (32 bits over 64)",
      swaccess: "none",
      hwaccess: "none",
      fields: [
        { bits: "31:0" }
      ],
    },
    { name: "Channel_Flags_c97",
      desc: "Defines wheter interrupts or polling is used for communication",
      swaccess: "rw",
      hwaccess: "none",
      fields: [
        { bits: "31:1" },
        { bits: "0",
          name: "intr_enable",
          desc: "If 1 interruts are used, if 0 polling is used"
        }
      ],
    },
    { name: "Length_c97",
      desc: "Lenght of payload + header",
      swaccess: "rw",
      hwaccess: "none",
      fields: [
        { bits: "31:0" }
      ],
    },
    { name: "Message_Header_c97",
      desc: "Defines which commanad the message contains",
      swaccess: "rw",
      hwaccess: "none",
      fields: [
        { bits: "31:28" },
        { bits: "27:18",
          name: "Token",
          desc: "must be same for the msg responses associated to a msg whith the same header"
        },
        { bits: "17:10",
          name: "Protocol_Id",
          desc: "Identifies to which protocol the command belongs to"
        },
        { bits: "9:8",
          name: "Message_Type",
          desc: "can be 0,1,2,3 depending on the kind of msg to be sent"
        },
        { bits: "7:0",
          name: "Message_Id",
          desc: "unique identifier for each command availabe in the protocol pointed by protocol_id"
        }
      ],
    },
    { name: "Message_Payload_1_c97",
      desc: "memory region dedicated to the parameters of the commands and their returns",
      swaccess: "rw",
      hwaccess: "none",
      fields: [
        { bits: "31:0" }
      ],
    },
    { name: "Doorbell_c97",
      desc: "Rapresents the interrupt to be raised towards the platform",
      swaccess: "rw",
      hwaccess: "hro",
      fields: [
        { bits: "31:1",
          name: "Preserve_Mask",
          desc: "These bits must be constant to 0, not used with just one platform and one agent"
        },
        { bits: "0",
          name: "intr",
          desc: "Interrupt bit"
        }
      ],
    },
    { name:  "Completion_Interrupt_c97",
      desc: "Rapresent the interrupt the platform should raise when it finishes to execute the received command",
      swaccess: "rw",
      hwaccess: "hro",
      fields: [
        { bits: "31:1",
          name: "Preserve_Mask",
          desc: "These bits must be constant to 0, not used with just one platform and one agent"
        },
        { bits: "0",
          name: "intr",
          desc: "Interrupt bit"
        }
      ],
    },
    { name: "Reserved_1_c98",
      desc: "Reserved, must be 0",
      swaccess: "rw",
      hwaccess: "none",
      fields: [
        { bits: "31:0" }
      ],
    },
    { name: "Channel_Status_c98",
      desc: "Indicates which entity has access to the Shared Memory",
      swaccess: "rw",
      hwaccess: "none",
      fields: [
        { bits: "31:2" },
        { bits: "1",
          name: "channel_error",
          desc: "Must be 0 in absence of errors"
        },
        { bits: "0",
          name: "channel_free",
          desc: "If 1 the agent own the channel, if 0 the platform own the channel"
        }
      ],
    },
    { name: "Reserved_2_c98",
      desc: "Reserved, implementation defined (32 bits over 64)",
      swaccess: "rw",
      hwaccess: "none",
      fields: [
        { bits: "31:0" }
      ],
    },
    { name: "Reserved_3_c98",
      desc: "Reserved, implementation defined (32 bits over 64)",
      swaccess: "none",
      hwaccess: "none",
      fields: [
        { bits: "31:0" }
      ],
    },
    { name: "Channel_Flags_c98",
      desc: "Defines wheter interrupts or polling is used for communication",
      swaccess: "rw",
      hwaccess: "none",
      fields: [
        { bits: "31:1" },
        { bits: "0",
          name: "intr_enable",
          desc: "If 1 interruts are used, if 0 polling is used"
        }
      ],
    },
    { name: "Length_c98",
      desc: "Lenght of payload + header",
      swaccess: "rw",
      hwaccess: "none",
      fields: [
        { bits: "31:0" }
      ],
    },
    { name: "Message_Header_c98",
      desc: "Defines which commanad the message contains",
      swaccess: "rw",
      hwaccess: "none",
      fields: [
        { bits: "31:28" },
        { bits: "27:18",
          name: "Token",
          desc: "must be same for the msg responses associated to a msg whith the same header"
        },
        { bits: "17:10",
          name: "Protocol_Id",
          desc: "Identifies to which protocol the command belongs to"
        },
        { bits: "9:8",
          name: "Message_Type",
          desc: "can be 0,1,2,3 depending on the kind of msg to be sent"
        },
        { bits: "7:0",
          name: "Message_Id",
          desc: "unique identifier for each command availabe in the protocol pointed by protocol_id"
        }
      ],
    },
    { name: "Message_Payload_1_c98",
      desc: "memory region dedicated to the parameters of the commands and their returns",
      swaccess: "rw",
      hwaccess: "none",
      fields: [
        { bits: "31:0" }
      ],
    },
    { name: "Doorbell_c98",
      desc: "Rapresents the interrupt to be raised towards the platform",
      swaccess: "rw",
      hwaccess: "hro",
      fields: [
        { bits: "31:1",
          name: "Preserve_Mask",
          desc: "These bits must be constant to 0, not used with just one platform and one agent"
        },
        { bits: "0",
          name: "intr",
          desc: "Interrupt bit"
        }
      ],
    },
    { name:  "Completion_Interrupt_c98",
      desc: "Rapresent the interrupt the platform should raise when it finishes to execute the received command",
      swaccess: "rw",
      hwaccess: "hro",
      fields: [
        { bits: "31:1",
          name: "Preserve_Mask",
          desc: "These bits must be constant to 0, not used with just one platform and one agent"
        },
        { bits: "0",
          name: "intr",
          desc: "Interrupt bit"
        }
      ],
    },
    { name: "Reserved_1_c99",
      desc: "Reserved, must be 0",
      swaccess: "rw",
      hwaccess: "none",
      fields: [
        { bits: "31:0" }
      ],
    },
    { name: "Channel_Status_c99",
      desc: "Indicates which entity has access to the Shared Memory",
      swaccess: "rw",
      hwaccess: "none",
      fields: [
        { bits: "31:2" },
        { bits: "1",
          name: "channel_error",
          desc: "Must be 0 in absence of errors"
        },
        { bits: "0",
          name: "channel_free",
          desc: "If 1 the agent own the channel, if 0 the platform own the channel"
        }
      ],
    },
    { name: "Reserved_2_c99",
      desc: "Reserved, implementation defined (32 bits over 64)",
      swaccess: "rw",
      hwaccess: "none",
      fields: [
        { bits: "31:0" }
      ],
    },
    { name: "Reserved_3_c99",
      desc: "Reserved, implementation defined (32 bits over 64)",
      swaccess: "none",
      hwaccess: "none",
      fields: [
        { bits: "31:0" }
      ],
    },
    { name: "Channel_Flags_c99",
      desc: "Defines wheter interrupts or polling is used for communication",
      swaccess: "rw",
      hwaccess: "none",
      fields: [
        { bits: "31:1" },
        { bits: "0",
          name: "intr_enable",
          desc: "If 1 interruts are used, if 0 polling is used"
        }
      ],
    },
    { name: "Length_c99",
      desc: "Lenght of payload + header",
      swaccess: "rw",
      hwaccess: "none",
      fields: [
        { bits: "31:0" }
      ],
    },
    { name: "Message_Header_c99",
      desc: "Defines which commanad the message contains",
      swaccess: "rw",
      hwaccess: "none",
      fields: [
        { bits: "31:28" },
        { bits: "27:18",
          name: "Token",
          desc: "must be same for the msg responses associated to a msg whith the same header"
        },
        { bits: "17:10",
          name: "Protocol_Id",
          desc: "Identifies to which protocol the command belongs to"
        },
        { bits: "9:8",
          name: "Message_Type",
          desc: "can be 0,1,2,3 depending on the kind of msg to be sent"
        },
        { bits: "7:0",
          name: "Message_Id",
          desc: "unique identifier for each command availabe in the protocol pointed by protocol_id"
        }
      ],
    },
    { name: "Message_Payload_1_c99",
      desc: "memory region dedicated to the parameters of the commands and their returns",
      swaccess: "rw",
      hwaccess: "none",
      fields: [
        { bits: "31:0" }
      ],
    },
    { name: "Doorbell_c99",
      desc: "Rapresents the interrupt to be raised towards the platform",
      swaccess: "rw",
      hwaccess: "hro",
      fields: [
        { bits: "31:1",
          name: "Preserve_Mask",
          desc: "These bits must be constant to 0, not used with just one platform and one agent"
        },
        { bits: "0",
          name: "intr",
          desc: "Interrupt bit"
        }
      ],
    },
    { name:  "Completion_Interrupt_c99",
      desc: "Rapresent the interrupt the platform should raise when it finishes to execute the received command",
      swaccess: "rw",
      hwaccess: "hro",
      fields: [
        { bits: "31:1",
          name: "Preserve_Mask",
          desc: "These bits must be constant to 0, not used with just one platform and one agent"
        },
        { bits: "0",
          name: "intr",
          desc: "Interrupt bit"
        }
      ],
    },
    { name: "Reserved_1_c100",
      desc: "Reserved, must be 0",
      swaccess: "rw",
      hwaccess: "none",
      fields: [
        { bits: "31:0" }
      ],
    },
    { name: "Channel_Status_c100",
      desc: "Indicates which entity has access to the Shared Memory",
      swaccess: "rw",
      hwaccess: "none",
      fields: [
        { bits: "31:2" },
        { bits: "1",
          name: "channel_error",
          desc: "Must be 0 in absence of errors"
        },
        { bits: "0",
          name: "channel_free",
          desc: "If 1 the agent own the channel, if 0 the platform own the channel"
        }
      ],
    },
    { name: "Reserved_2_c100",
      desc: "Reserved, implementation defined (32 bits over 64)",
      swaccess: "rw",
      hwaccess: "none",
      fields: [
        { bits: "31:0" }
      ],
    },
    { name: "Reserved_3_c100",
      desc: "Reserved, implementation defined (32 bits over 64)",
      swaccess: "none",
      hwaccess: "none",
      fields: [
        { bits: "31:0" }
      ],
    },
    { name: "Channel_Flags_c100",
      desc: "Defines wheter interrupts or polling is used for communication",
      swaccess: "rw",
      hwaccess: "none",
      fields: [
        { bits: "31:1" },
        { bits: "0",
          name: "intr_enable",
          desc: "If 1 interruts are used, if 0 polling is used"
        }
      ],
    },
    { name: "Length_c100",
      desc: "Lenght of payload + header",
      swaccess: "rw",
      hwaccess: "none",
      fields: [
        { bits: "31:0" }
      ],
    },
    { name: "Message_Header_c100",
      desc: "Defines which commanad the message contains",
      swaccess: "rw",
      hwaccess: "none",
      fields: [
        { bits: "31:28" },
        { bits: "27:18",
          name: "Token",
          desc: "must be same for the msg responses associated to a msg whith the same header"
        },
        { bits: "17:10",
          name: "Protocol_Id",
          desc: "Identifies to which protocol the command belongs to"
        },
        { bits: "9:8",
          name: "Message_Type",
          desc: "can be 0,1,2,3 depending on the kind of msg to be sent"
        },
        { bits: "7:0",
          name: "Message_Id",
          desc: "unique identifier for each command availabe in the protocol pointed by protocol_id"
        }
      ],
    },
    { name: "Message_Payload_1_c100",
      desc: "memory region dedicated to the parameters of the commands and their returns",
      swaccess: "rw",
      hwaccess: "none",
      fields: [
        { bits: "31:0" }
      ],
    },
    { name: "Doorbell_c100",
      desc: "Rapresents the interrupt to be raised towards the platform",
      swaccess: "rw",
      hwaccess: "hro",
      fields: [
        { bits: "31:1",
          name: "Preserve_Mask",
          desc: "These bits must be constant to 0, not used with just one platform and one agent"
        },
        { bits: "0",
          name: "intr",
          desc: "Interrupt bit"
        }
      ],
    },
    { name:  "Completion_Interrupt_c100",
      desc: "Rapresent the interrupt the platform should raise when it finishes to execute the received command",
      swaccess: "rw",
      hwaccess: "hro",
      fields: [
        { bits: "31:1",
          name: "Preserve_Mask",
          desc: "These bits must be constant to 0, not used with just one platform and one agent"
        },
        { bits: "0",
          name: "intr",
          desc: "Interrupt bit"
        }
      ],
    },
    { name: "Reserved_1_c101",
      desc: "Reserved, must be 0",
      swaccess: "rw",
      hwaccess: "none",
      fields: [
        { bits: "31:0" }
      ],
    },
    { name: "Channel_Status_c101",
      desc: "Indicates which entity has access to the Shared Memory",
      swaccess: "rw",
      hwaccess: "none",
      fields: [
        { bits: "31:2" },
        { bits: "1",
          name: "channel_error",
          desc: "Must be 0 in absence of errors"
        },
        { bits: "0",
          name: "channel_free",
          desc: "If 1 the agent own the channel, if 0 the platform own the channel"
        }
      ],
    },
    { name: "Reserved_2_c101",
      desc: "Reserved, implementation defined (32 bits over 64)",
      swaccess: "rw",
      hwaccess: "none",
      fields: [
        { bits: "31:0" }
      ],
    },
    { name: "Reserved_3_c101",
      desc: "Reserved, implementation defined (32 bits over 64)",
      swaccess: "none",
      hwaccess: "none",
      fields: [
        { bits: "31:0" }
      ],
    },
    { name: "Channel_Flags_c101",
      desc: "Defines wheter interrupts or polling is used for communication",
      swaccess: "rw",
      hwaccess: "none",
      fields: [
        { bits: "31:1" },
        { bits: "0",
          name: "intr_enable",
          desc: "If 1 interruts are used, if 0 polling is used"
        }
      ],
    },
    { name: "Length_c101",
      desc: "Lenght of payload + header",
      swaccess: "rw",
      hwaccess: "none",
      fields: [
        { bits: "31:0" }
      ],
    },
    { name: "Message_Header_c101",
      desc: "Defines which commanad the message contains",
      swaccess: "rw",
      hwaccess: "none",
      fields: [
        { bits: "31:28" },
        { bits: "27:18",
          name: "Token",
          desc: "must be same for the msg responses associated to a msg whith the same header"
        },
        { bits: "17:10",
          name: "Protocol_Id",
          desc: "Identifies to which protocol the command belongs to"
        },
        { bits: "9:8",
          name: "Message_Type",
          desc: "can be 0,1,2,3 depending on the kind of msg to be sent"
        },
        { bits: "7:0",
          name: "Message_Id",
          desc: "unique identifier for each command availabe in the protocol pointed by protocol_id"
        }
      ],
    },
    { name: "Message_Payload_1_c101",
      desc: "memory region dedicated to the parameters of the commands and their returns",
      swaccess: "rw",
      hwaccess: "none",
      fields: [
        { bits: "31:0" }
      ],
    },
    { name: "Doorbell_c101",
      desc: "Rapresents the interrupt to be raised towards the platform",
      swaccess: "rw",
      hwaccess: "hro",
      fields: [
        { bits: "31:1",
          name: "Preserve_Mask",
          desc: "These bits must be constant to 0, not used with just one platform and one agent"
        },
        { bits: "0",
          name: "intr",
          desc: "Interrupt bit"
        }
      ],
    },
    { name:  "Completion_Interrupt_c101",
      desc: "Rapresent the interrupt the platform should raise when it finishes to execute the received command",
      swaccess: "rw",
      hwaccess: "hro",
      fields: [
        { bits: "31:1",
          name: "Preserve_Mask",
          desc: "These bits must be constant to 0, not used with just one platform and one agent"
        },
        { bits: "0",
          name: "intr",
          desc: "Interrupt bit"
        }
      ],
    },
    { name: "Reserved_1_c102",
      desc: "Reserved, must be 0",
      swaccess: "rw",
      hwaccess: "none",
      fields: [
        { bits: "31:0" }
      ],
    },
    { name: "Channel_Status_c102",
      desc: "Indicates which entity has access to the Shared Memory",
      swaccess: "rw",
      hwaccess: "none",
      fields: [
        { bits: "31:2" },
        { bits: "1",
          name: "channel_error",
          desc: "Must be 0 in absence of errors"
        },
        { bits: "0",
          name: "channel_free",
          desc: "If 1 the agent own the channel, if 0 the platform own the channel"
        }
      ],
    },
    { name: "Reserved_2_c102",
      desc: "Reserved, implementation defined (32 bits over 64)",
      swaccess: "rw",
      hwaccess: "none",
      fields: [
        { bits: "31:0" }
      ],
    },
    { name: "Reserved_3_c102",
      desc: "Reserved, implementation defined (32 bits over 64)",
      swaccess: "none",
      hwaccess: "none",
      fields: [
        { bits: "31:0" }
      ],
    },
    { name: "Channel_Flags_c102",
      desc: "Defines wheter interrupts or polling is used for communication",
      swaccess: "rw",
      hwaccess: "none",
      fields: [
        { bits: "31:1" },
        { bits: "0",
          name: "intr_enable",
          desc: "If 1 interruts are used, if 0 polling is used"
        }
      ],
    },
    { name: "Length_c102",
      desc: "Lenght of payload + header",
      swaccess: "rw",
      hwaccess: "none",
      fields: [
        { bits: "31:0" }
      ],
    },
    { name: "Message_Header_c102",
      desc: "Defines which commanad the message contains",
      swaccess: "rw",
      hwaccess: "none",
      fields: [
        { bits: "31:28" },
        { bits: "27:18",
          name: "Token",
          desc: "must be same for the msg responses associated to a msg whith the same header"
        },
        { bits: "17:10",
          name: "Protocol_Id",
          desc: "Identifies to which protocol the command belongs to"
        },
        { bits: "9:8",
          name: "Message_Type",
          desc: "can be 0,1,2,3 depending on the kind of msg to be sent"
        },
        { bits: "7:0",
          name: "Message_Id",
          desc: "unique identifier for each command availabe in the protocol pointed by protocol_id"
        }
      ],
    },
    { name: "Message_Payload_1_c102",
      desc: "memory region dedicated to the parameters of the commands and their returns",
      swaccess: "rw",
      hwaccess: "none",
      fields: [
        { bits: "31:0" }
      ],
    },
    { name: "Doorbell_c102",
      desc: "Rapresents the interrupt to be raised towards the platform",
      swaccess: "rw",
      hwaccess: "hro",
      fields: [
        { bits: "31:1",
          name: "Preserve_Mask",
          desc: "These bits must be constant to 0, not used with just one platform and one agent"
        },
        { bits: "0",
          name: "intr",
          desc: "Interrupt bit"
        }
      ],
    },
    { name:  "Completion_Interrupt_c102",
      desc: "Rapresent the interrupt the platform should raise when it finishes to execute the received command",
      swaccess: "rw",
      hwaccess: "hro",
      fields: [
        { bits: "31:1",
          name: "Preserve_Mask",
          desc: "These bits must be constant to 0, not used with just one platform and one agent"
        },
        { bits: "0",
          name: "intr",
          desc: "Interrupt bit"
        }
      ],
    },
    { name: "Reserved_1_c103",
      desc: "Reserved, must be 0",
      swaccess: "rw",
      hwaccess: "none",
      fields: [
        { bits: "31:0" }
      ],
    },
    { name: "Channel_Status_c103",
      desc: "Indicates which entity has access to the Shared Memory",
      swaccess: "rw",
      hwaccess: "none",
      fields: [
        { bits: "31:2" },
        { bits: "1",
          name: "channel_error",
          desc: "Must be 0 in absence of errors"
        },
        { bits: "0",
          name: "channel_free",
          desc: "If 1 the agent own the channel, if 0 the platform own the channel"
        }
      ],
    },
    { name: "Reserved_2_c103",
      desc: "Reserved, implementation defined (32 bits over 64)",
      swaccess: "rw",
      hwaccess: "none",
      fields: [
        { bits: "31:0" }
      ],
    },
    { name: "Reserved_3_c103",
      desc: "Reserved, implementation defined (32 bits over 64)",
      swaccess: "none",
      hwaccess: "none",
      fields: [
        { bits: "31:0" }
      ],
    },
    { name: "Channel_Flags_c103",
      desc: "Defines wheter interrupts or polling is used for communication",
      swaccess: "rw",
      hwaccess: "none",
      fields: [
        { bits: "31:1" },
        { bits: "0",
          name: "intr_enable",
          desc: "If 1 interruts are used, if 0 polling is used"
        }
      ],
    },
    { name: "Length_c103",
      desc: "Lenght of payload + header",
      swaccess: "rw",
      hwaccess: "none",
      fields: [
        { bits: "31:0" }
      ],
    },
    { name: "Message_Header_c103",
      desc: "Defines which commanad the message contains",
      swaccess: "rw",
      hwaccess: "none",
      fields: [
        { bits: "31:28" },
        { bits: "27:18",
          name: "Token",
          desc: "must be same for the msg responses associated to a msg whith the same header"
        },
        { bits: "17:10",
          name: "Protocol_Id",
          desc: "Identifies to which protocol the command belongs to"
        },
        { bits: "9:8",
          name: "Message_Type",
          desc: "can be 0,1,2,3 depending on the kind of msg to be sent"
        },
        { bits: "7:0",
          name: "Message_Id",
          desc: "unique identifier for each command availabe in the protocol pointed by protocol_id"
        }
      ],
    },
    { name: "Message_Payload_1_c103",
      desc: "memory region dedicated to the parameters of the commands and their returns",
      swaccess: "rw",
      hwaccess: "none",
      fields: [
        { bits: "31:0" }
      ],
    },
    { name: "Doorbell_c103",
      desc: "Rapresents the interrupt to be raised towards the platform",
      swaccess: "rw",
      hwaccess: "hro",
      fields: [
        { bits: "31:1",
          name: "Preserve_Mask",
          desc: "These bits must be constant to 0, not used with just one platform and one agent"
        },
        { bits: "0",
          name: "intr",
          desc: "Interrupt bit"
        }
      ],
    },
    { name:  "Completion_Interrupt_c103",
      desc: "Rapresent the interrupt the platform should raise when it finishes to execute the received command",
      swaccess: "rw",
      hwaccess: "hro",
      fields: [
        { bits: "31:1",
          name: "Preserve_Mask",
          desc: "These bits must be constant to 0, not used with just one platform and one agent"
        },
        { bits: "0",
          name: "intr",
          desc: "Interrupt bit"
        }
      ],
    },
    { name: "Reserved_1_c104",
      desc: "Reserved, must be 0",
      swaccess: "rw",
      hwaccess: "none",
      fields: [
        { bits: "31:0" }
      ],
    },
    { name: "Channel_Status_c104",
      desc: "Indicates which entity has access to the Shared Memory",
      swaccess: "rw",
      hwaccess: "none",
      fields: [
        { bits: "31:2" },
        { bits: "1",
          name: "channel_error",
          desc: "Must be 0 in absence of errors"
        },
        { bits: "0",
          name: "channel_free",
          desc: "If 1 the agent own the channel, if 0 the platform own the channel"
        }
      ],
    },
    { name: "Reserved_2_c104",
      desc: "Reserved, implementation defined (32 bits over 64)",
      swaccess: "rw",
      hwaccess: "none",
      fields: [
        { bits: "31:0" }
      ],
    },
    { name: "Reserved_3_c104",
      desc: "Reserved, implementation defined (32 bits over 64)",
      swaccess: "none",
      hwaccess: "none",
      fields: [
        { bits: "31:0" }
      ],
    },
    { name: "Channel_Flags_c104",
      desc: "Defines wheter interrupts or polling is used for communication",
      swaccess: "rw",
      hwaccess: "none",
      fields: [
        { bits: "31:1" },
        { bits: "0",
          name: "intr_enable",
          desc: "If 1 interruts are used, if 0 polling is used"
        }
      ],
    },
    { name: "Length_c104",
      desc: "Lenght of payload + header",
      swaccess: "rw",
      hwaccess: "none",
      fields: [
        { bits: "31:0" }
      ],
    },
    { name: "Message_Header_c104",
      desc: "Defines which commanad the message contains",
      swaccess: "rw",
      hwaccess: "none",
      fields: [
        { bits: "31:28" },
        { bits: "27:18",
          name: "Token",
          desc: "must be same for the msg responses associated to a msg whith the same header"
        },
        { bits: "17:10",
          name: "Protocol_Id",
          desc: "Identifies to which protocol the command belongs to"
        },
        { bits: "9:8",
          name: "Message_Type",
          desc: "can be 0,1,2,3 depending on the kind of msg to be sent"
        },
        { bits: "7:0",
          name: "Message_Id",
          desc: "unique identifier for each command availabe in the protocol pointed by protocol_id"
        }
      ],
    },
    { name: "Message_Payload_1_c104",
      desc: "memory region dedicated to the parameters of the commands and their returns",
      swaccess: "rw",
      hwaccess: "none",
      fields: [
        { bits: "31:0" }
      ],
    },
    { name: "Doorbell_c104",
      desc: "Rapresents the interrupt to be raised towards the platform",
      swaccess: "rw",
      hwaccess: "hro",
      fields: [
        { bits: "31:1",
          name: "Preserve_Mask",
          desc: "These bits must be constant to 0, not used with just one platform and one agent"
        },
        { bits: "0",
          name: "intr",
          desc: "Interrupt bit"
        }
      ],
    },
    { name:  "Completion_Interrupt_c104",
      desc: "Rapresent the interrupt the platform should raise when it finishes to execute the received command",
      swaccess: "rw",
      hwaccess: "hro",
      fields: [
        { bits: "31:1",
          name: "Preserve_Mask",
          desc: "These bits must be constant to 0, not used with just one platform and one agent"
        },
        { bits: "0",
          name: "intr",
          desc: "Interrupt bit"
        }
      ],
    },
    { name: "Reserved_1_c105",
      desc: "Reserved, must be 0",
      swaccess: "rw",
      hwaccess: "none",
      fields: [
        { bits: "31:0" }
      ],
    },
    { name: "Channel_Status_c105",
      desc: "Indicates which entity has access to the Shared Memory",
      swaccess: "rw",
      hwaccess: "none",
      fields: [
        { bits: "31:2" },
        { bits: "1",
          name: "channel_error",
          desc: "Must be 0 in absence of errors"
        },
        { bits: "0",
          name: "channel_free",
          desc: "If 1 the agent own the channel, if 0 the platform own the channel"
        }
      ],
    },
    { name: "Reserved_2_c105",
      desc: "Reserved, implementation defined (32 bits over 64)",
      swaccess: "rw",
      hwaccess: "none",
      fields: [
        { bits: "31:0" }
      ],
    },
    { name: "Reserved_3_c105",
      desc: "Reserved, implementation defined (32 bits over 64)",
      swaccess: "none",
      hwaccess: "none",
      fields: [
        { bits: "31:0" }
      ],
    },
    { name: "Channel_Flags_c105",
      desc: "Defines wheter interrupts or polling is used for communication",
      swaccess: "rw",
      hwaccess: "none",
      fields: [
        { bits: "31:1" },
        { bits: "0",
          name: "intr_enable",
          desc: "If 1 interruts are used, if 0 polling is used"
        }
      ],
    },
    { name: "Length_c105",
      desc: "Lenght of payload + header",
      swaccess: "rw",
      hwaccess: "none",
      fields: [
        { bits: "31:0" }
      ],
    },
    { name: "Message_Header_c105",
      desc: "Defines which commanad the message contains",
      swaccess: "rw",
      hwaccess: "none",
      fields: [
        { bits: "31:28" },
        { bits: "27:18",
          name: "Token",
          desc: "must be same for the msg responses associated to a msg whith the same header"
        },
        { bits: "17:10",
          name: "Protocol_Id",
          desc: "Identifies to which protocol the command belongs to"
        },
        { bits: "9:8",
          name: "Message_Type",
          desc: "can be 0,1,2,3 depending on the kind of msg to be sent"
        },
        { bits: "7:0",
          name: "Message_Id",
          desc: "unique identifier for each command availabe in the protocol pointed by protocol_id"
        }
      ],
    },
    { name: "Message_Payload_1_c105",
      desc: "memory region dedicated to the parameters of the commands and their returns",
      swaccess: "rw",
      hwaccess: "none",
      fields: [
        { bits: "31:0" }
      ],
    },
    { name: "Doorbell_c105",
      desc: "Rapresents the interrupt to be raised towards the platform",
      swaccess: "rw",
      hwaccess: "hro",
      fields: [
        { bits: "31:1",
          name: "Preserve_Mask",
          desc: "These bits must be constant to 0, not used with just one platform and one agent"
        },
        { bits: "0",
          name: "intr",
          desc: "Interrupt bit"
        }
      ],
    },
    { name:  "Completion_Interrupt_c105",
      desc: "Rapresent the interrupt the platform should raise when it finishes to execute the received command",
      swaccess: "rw",
      hwaccess: "hro",
      fields: [
        { bits: "31:1",
          name: "Preserve_Mask",
          desc: "These bits must be constant to 0, not used with just one platform and one agent"
        },
        { bits: "0",
          name: "intr",
          desc: "Interrupt bit"
        }
      ],
    },
    { name: "Reserved_1_c106",
      desc: "Reserved, must be 0",
      swaccess: "rw",
      hwaccess: "none",
      fields: [
        { bits: "31:0" }
      ],
    },
    { name: "Channel_Status_c106",
      desc: "Indicates which entity has access to the Shared Memory",
      swaccess: "rw",
      hwaccess: "none",
      fields: [
        { bits: "31:2" },
        { bits: "1",
          name: "channel_error",
          desc: "Must be 0 in absence of errors"
        },
        { bits: "0",
          name: "channel_free",
          desc: "If 1 the agent own the channel, if 0 the platform own the channel"
        }
      ],
    },
    { name: "Reserved_2_c106",
      desc: "Reserved, implementation defined (32 bits over 64)",
      swaccess: "rw",
      hwaccess: "none",
      fields: [
        { bits: "31:0" }
      ],
    },
    { name: "Reserved_3_c106",
      desc: "Reserved, implementation defined (32 bits over 64)",
      swaccess: "none",
      hwaccess: "none",
      fields: [
        { bits: "31:0" }
      ],
    },
    { name: "Channel_Flags_c106",
      desc: "Defines wheter interrupts or polling is used for communication",
      swaccess: "rw",
      hwaccess: "none",
      fields: [
        { bits: "31:1" },
        { bits: "0",
          name: "intr_enable",
          desc: "If 1 interruts are used, if 0 polling is used"
        }
      ],
    },
    { name: "Length_c106",
      desc: "Lenght of payload + header",
      swaccess: "rw",
      hwaccess: "none",
      fields: [
        { bits: "31:0" }
      ],
    },
    { name: "Message_Header_c106",
      desc: "Defines which commanad the message contains",
      swaccess: "rw",
      hwaccess: "none",
      fields: [
        { bits: "31:28" },
        { bits: "27:18",
          name: "Token",
          desc: "must be same for the msg responses associated to a msg whith the same header"
        },
        { bits: "17:10",
          name: "Protocol_Id",
          desc: "Identifies to which protocol the command belongs to"
        },
        { bits: "9:8",
          name: "Message_Type",
          desc: "can be 0,1,2,3 depending on the kind of msg to be sent"
        },
        { bits: "7:0",
          name: "Message_Id",
          desc: "unique identifier for each command availabe in the protocol pointed by protocol_id"
        }
      ],
    },
    { name: "Message_Payload_1_c106",
      desc: "memory region dedicated to the parameters of the commands and their returns",
      swaccess: "rw",
      hwaccess: "none",
      fields: [
        { bits: "31:0" }
      ],
    },
    { name: "Doorbell_c106",
      desc: "Rapresents the interrupt to be raised towards the platform",
      swaccess: "rw",
      hwaccess: "hro",
      fields: [
        { bits: "31:1",
          name: "Preserve_Mask",
          desc: "These bits must be constant to 0, not used with just one platform and one agent"
        },
        { bits: "0",
          name: "intr",
          desc: "Interrupt bit"
        }
      ],
    },
    { name:  "Completion_Interrupt_c106",
      desc: "Rapresent the interrupt the platform should raise when it finishes to execute the received command",
      swaccess: "rw",
      hwaccess: "hro",
      fields: [
        { bits: "31:1",
          name: "Preserve_Mask",
          desc: "These bits must be constant to 0, not used with just one platform and one agent"
        },
        { bits: "0",
          name: "intr",
          desc: "Interrupt bit"
        }
      ],
    },
    { name: "Reserved_1_c107",
      desc: "Reserved, must be 0",
      swaccess: "rw",
      hwaccess: "none",
      fields: [
        { bits: "31:0" }
      ],
    },
    { name: "Channel_Status_c107",
      desc: "Indicates which entity has access to the Shared Memory",
      swaccess: "rw",
      hwaccess: "none",
      fields: [
        { bits: "31:2" },
        { bits: "1",
          name: "channel_error",
          desc: "Must be 0 in absence of errors"
        },
        { bits: "0",
          name: "channel_free",
          desc: "If 1 the agent own the channel, if 0 the platform own the channel"
        }
      ],
    },
    { name: "Reserved_2_c107",
      desc: "Reserved, implementation defined (32 bits over 64)",
      swaccess: "rw",
      hwaccess: "none",
      fields: [
        { bits: "31:0" }
      ],
    },
    { name: "Reserved_3_c107",
      desc: "Reserved, implementation defined (32 bits over 64)",
      swaccess: "none",
      hwaccess: "none",
      fields: [
        { bits: "31:0" }
      ],
    },
    { name: "Channel_Flags_c107",
      desc: "Defines wheter interrupts or polling is used for communication",
      swaccess: "rw",
      hwaccess: "none",
      fields: [
        { bits: "31:1" },
        { bits: "0",
          name: "intr_enable",
          desc: "If 1 interruts are used, if 0 polling is used"
        }
      ],
    },
    { name: "Length_c107",
      desc: "Lenght of payload + header",
      swaccess: "rw",
      hwaccess: "none",
      fields: [
        { bits: "31:0" }
      ],
    },
    { name: "Message_Header_c107",
      desc: "Defines which commanad the message contains",
      swaccess: "rw",
      hwaccess: "none",
      fields: [
        { bits: "31:28" },
        { bits: "27:18",
          name: "Token",
          desc: "must be same for the msg responses associated to a msg whith the same header"
        },
        { bits: "17:10",
          name: "Protocol_Id",
          desc: "Identifies to which protocol the command belongs to"
        },
        { bits: "9:8",
          name: "Message_Type",
          desc: "can be 0,1,2,3 depending on the kind of msg to be sent"
        },
        { bits: "7:0",
          name: "Message_Id",
          desc: "unique identifier for each command availabe in the protocol pointed by protocol_id"
        }
      ],
    },
    { name: "Message_Payload_1_c107",
      desc: "memory region dedicated to the parameters of the commands and their returns",
      swaccess: "rw",
      hwaccess: "none",
      fields: [
        { bits: "31:0" }
      ],
    },
    { name: "Doorbell_c107",
      desc: "Rapresents the interrupt to be raised towards the platform",
      swaccess: "rw",
      hwaccess: "hro",
      fields: [
        { bits: "31:1",
          name: "Preserve_Mask",
          desc: "These bits must be constant to 0, not used with just one platform and one agent"
        },
        { bits: "0",
          name: "intr",
          desc: "Interrupt bit"
        }
      ],
    },
    { name:  "Completion_Interrupt_c107",
      desc: "Rapresent the interrupt the platform should raise when it finishes to execute the received command",
      swaccess: "rw",
      hwaccess: "hro",
      fields: [
        { bits: "31:1",
          name: "Preserve_Mask",
          desc: "These bits must be constant to 0, not used with just one platform and one agent"
        },
        { bits: "0",
          name: "intr",
          desc: "Interrupt bit"
        }
      ],
    },
    { name: "Reserved_1_c108",
      desc: "Reserved, must be 0",
      swaccess: "rw",
      hwaccess: "none",
      fields: [
        { bits: "31:0" }
      ],
    },
    { name: "Channel_Status_c108",
      desc: "Indicates which entity has access to the Shared Memory",
      swaccess: "rw",
      hwaccess: "none",
      fields: [
        { bits: "31:2" },
        { bits: "1",
          name: "channel_error",
          desc: "Must be 0 in absence of errors"
        },
        { bits: "0",
          name: "channel_free",
          desc: "If 1 the agent own the channel, if 0 the platform own the channel"
        }
      ],
    },
    { name: "Reserved_2_c108",
      desc: "Reserved, implementation defined (32 bits over 64)",
      swaccess: "rw",
      hwaccess: "none",
      fields: [
        { bits: "31:0" }
      ],
    },
    { name: "Reserved_3_c108",
      desc: "Reserved, implementation defined (32 bits over 64)",
      swaccess: "none",
      hwaccess: "none",
      fields: [
        { bits: "31:0" }
      ],
    },
    { name: "Channel_Flags_c108",
      desc: "Defines wheter interrupts or polling is used for communication",
      swaccess: "rw",
      hwaccess: "none",
      fields: [
        { bits: "31:1" },
        { bits: "0",
          name: "intr_enable",
          desc: "If 1 interruts are used, if 0 polling is used"
        }
      ],
    },
    { name: "Length_c108",
      desc: "Lenght of payload + header",
      swaccess: "rw",
      hwaccess: "none",
      fields: [
        { bits: "31:0" }
      ],
    },
    { name: "Message_Header_c108",
      desc: "Defines which commanad the message contains",
      swaccess: "rw",
      hwaccess: "none",
      fields: [
        { bits: "31:28" },
        { bits: "27:18",
          name: "Token",
          desc: "must be same for the msg responses associated to a msg whith the same header"
        },
        { bits: "17:10",
          name: "Protocol_Id",
          desc: "Identifies to which protocol the command belongs to"
        },
        { bits: "9:8",
          name: "Message_Type",
          desc: "can be 0,1,2,3 depending on the kind of msg to be sent"
        },
        { bits: "7:0",
          name: "Message_Id",
          desc: "unique identifier for each command availabe in the protocol pointed by protocol_id"
        }
      ],
    },
    { name: "Message_Payload_1_c108",
      desc: "memory region dedicated to the parameters of the commands and their returns",
      swaccess: "rw",
      hwaccess: "none",
      fields: [
        { bits: "31:0" }
      ],
    },
    { name: "Doorbell_c108",
      desc: "Rapresents the interrupt to be raised towards the platform",
      swaccess: "rw",
      hwaccess: "hro",
      fields: [
        { bits: "31:1",
          name: "Preserve_Mask",
          desc: "These bits must be constant to 0, not used with just one platform and one agent"
        },
        { bits: "0",
          name: "intr",
          desc: "Interrupt bit"
        }
      ],
    },
    { name:  "Completion_Interrupt_c108",
      desc: "Rapresent the interrupt the platform should raise when it finishes to execute the received command",
      swaccess: "rw",
      hwaccess: "hro",
      fields: [
        { bits: "31:1",
          name: "Preserve_Mask",
          desc: "These bits must be constant to 0, not used with just one platform and one agent"
        },
        { bits: "0",
          name: "intr",
          desc: "Interrupt bit"
        }
      ],
    },
    { name: "Reserved_1_c109",
      desc: "Reserved, must be 0",
      swaccess: "rw",
      hwaccess: "none",
      fields: [
        { bits: "31:0" }
      ],
    },
    { name: "Channel_Status_c109",
      desc: "Indicates which entity has access to the Shared Memory",
      swaccess: "rw",
      hwaccess: "none",
      fields: [
        { bits: "31:2" },
        { bits: "1",
          name: "channel_error",
          desc: "Must be 0 in absence of errors"
        },
        { bits: "0",
          name: "channel_free",
          desc: "If 1 the agent own the channel, if 0 the platform own the channel"
        }
      ],
    },
    { name: "Reserved_2_c109",
      desc: "Reserved, implementation defined (32 bits over 64)",
      swaccess: "rw",
      hwaccess: "none",
      fields: [
        { bits: "31:0" }
      ],
    },
    { name: "Reserved_3_c109",
      desc: "Reserved, implementation defined (32 bits over 64)",
      swaccess: "none",
      hwaccess: "none",
      fields: [
        { bits: "31:0" }
      ],
    },
    { name: "Channel_Flags_c109",
      desc: "Defines wheter interrupts or polling is used for communication",
      swaccess: "rw",
      hwaccess: "none",
      fields: [
        { bits: "31:1" },
        { bits: "0",
          name: "intr_enable",
          desc: "If 1 interruts are used, if 0 polling is used"
        }
      ],
    },
    { name: "Length_c109",
      desc: "Lenght of payload + header",
      swaccess: "rw",
      hwaccess: "none",
      fields: [
        { bits: "31:0" }
      ],
    },
    { name: "Message_Header_c109",
      desc: "Defines which commanad the message contains",
      swaccess: "rw",
      hwaccess: "none",
      fields: [
        { bits: "31:28" },
        { bits: "27:18",
          name: "Token",
          desc: "must be same for the msg responses associated to a msg whith the same header"
        },
        { bits: "17:10",
          name: "Protocol_Id",
          desc: "Identifies to which protocol the command belongs to"
        },
        { bits: "9:8",
          name: "Message_Type",
          desc: "can be 0,1,2,3 depending on the kind of msg to be sent"
        },
        { bits: "7:0",
          name: "Message_Id",
          desc: "unique identifier for each command availabe in the protocol pointed by protocol_id"
        }
      ],
    },
    { name: "Message_Payload_1_c109",
      desc: "memory region dedicated to the parameters of the commands and their returns",
      swaccess: "rw",
      hwaccess: "none",
      fields: [
        { bits: "31:0" }
      ],
    },
    { name: "Doorbell_c109",
      desc: "Rapresents the interrupt to be raised towards the platform",
      swaccess: "rw",
      hwaccess: "hro",
      fields: [
        { bits: "31:1",
          name: "Preserve_Mask",
          desc: "These bits must be constant to 0, not used with just one platform and one agent"
        },
        { bits: "0",
          name: "intr",
          desc: "Interrupt bit"
        }
      ],
    },
    { name:  "Completion_Interrupt_c109",
      desc: "Rapresent the interrupt the platform should raise when it finishes to execute the received command",
      swaccess: "rw",
      hwaccess: "hro",
      fields: [
        { bits: "31:1",
          name: "Preserve_Mask",
          desc: "These bits must be constant to 0, not used with just one platform and one agent"
        },
        { bits: "0",
          name: "intr",
          desc: "Interrupt bit"
        }
      ],
    },
    { name: "Reserved_1_c110",
      desc: "Reserved, must be 0",
      swaccess: "rw",
      hwaccess: "none",
      fields: [
        { bits: "31:0" }
      ],
    },
    { name: "Channel_Status_c110",
      desc: "Indicates which entity has access to the Shared Memory",
      swaccess: "rw",
      hwaccess: "none",
      fields: [
        { bits: "31:2" },
        { bits: "1",
          name: "channel_error",
          desc: "Must be 0 in absence of errors"
        },
        { bits: "0",
          name: "channel_free",
          desc: "If 1 the agent own the channel, if 0 the platform own the channel"
        }
      ],
    },
    { name: "Reserved_2_c110",
      desc: "Reserved, implementation defined (32 bits over 64)",
      swaccess: "rw",
      hwaccess: "none",
      fields: [
        { bits: "31:0" }
      ],
    },
    { name: "Reserved_3_c110",
      desc: "Reserved, implementation defined (32 bits over 64)",
      swaccess: "none",
      hwaccess: "none",
      fields: [
        { bits: "31:0" }
      ],
    },
    { name: "Channel_Flags_c110",
      desc: "Defines wheter interrupts or polling is used for communication",
      swaccess: "rw",
      hwaccess: "none",
      fields: [
        { bits: "31:1" },
        { bits: "0",
          name: "intr_enable",
          desc: "If 1 interruts are used, if 0 polling is used"
        }
      ],
    },
    { name: "Length_c110",
      desc: "Lenght of payload + header",
      swaccess: "rw",
      hwaccess: "none",
      fields: [
        { bits: "31:0" }
      ],
    },
    { name: "Message_Header_c110",
      desc: "Defines which commanad the message contains",
      swaccess: "rw",
      hwaccess: "none",
      fields: [
        { bits: "31:28" },
        { bits: "27:18",
          name: "Token",
          desc: "must be same for the msg responses associated to a msg whith the same header"
        },
        { bits: "17:10",
          name: "Protocol_Id",
          desc: "Identifies to which protocol the command belongs to"
        },
        { bits: "9:8",
          name: "Message_Type",
          desc: "can be 0,1,2,3 depending on the kind of msg to be sent"
        },
        { bits: "7:0",
          name: "Message_Id",
          desc: "unique identifier for each command availabe in the protocol pointed by protocol_id"
        }
      ],
    },
    { name: "Message_Payload_1_c110",
      desc: "memory region dedicated to the parameters of the commands and their returns",
      swaccess: "rw",
      hwaccess: "none",
      fields: [
        { bits: "31:0" }
      ],
    },
    { name: "Doorbell_c110",
      desc: "Rapresents the interrupt to be raised towards the platform",
      swaccess: "rw",
      hwaccess: "hro",
      fields: [
        { bits: "31:1",
          name: "Preserve_Mask",
          desc: "These bits must be constant to 0, not used with just one platform and one agent"
        },
        { bits: "0",
          name: "intr",
          desc: "Interrupt bit"
        }
      ],
    },
    { name:  "Completion_Interrupt_c110",
      desc: "Rapresent the interrupt the platform should raise when it finishes to execute the received command",
      swaccess: "rw",
      hwaccess: "hro",
      fields: [
        { bits: "31:1",
          name: "Preserve_Mask",
          desc: "These bits must be constant to 0, not used with just one platform and one agent"
        },
        { bits: "0",
          name: "intr",
          desc: "Interrupt bit"
        }
      ],
    },
    { name: "Reserved_1_c111",
      desc: "Reserved, must be 0",
      swaccess: "rw",
      hwaccess: "none",
      fields: [
        { bits: "31:0" }
      ],
    },
    { name: "Channel_Status_c111",
      desc: "Indicates which entity has access to the Shared Memory",
      swaccess: "rw",
      hwaccess: "none",
      fields: [
        { bits: "31:2" },
        { bits: "1",
          name: "channel_error",
          desc: "Must be 0 in absence of errors"
        },
        { bits: "0",
          name: "channel_free",
          desc: "If 1 the agent own the channel, if 0 the platform own the channel"
        }
      ],
    },
    { name: "Reserved_2_c111",
      desc: "Reserved, implementation defined (32 bits over 64)",
      swaccess: "rw",
      hwaccess: "none",
      fields: [
        { bits: "31:0" }
      ],
    },
    { name: "Reserved_3_c111",
      desc: "Reserved, implementation defined (32 bits over 64)",
      swaccess: "none",
      hwaccess: "none",
      fields: [
        { bits: "31:0" }
      ],
    },
    { name: "Channel_Flags_c111",
      desc: "Defines wheter interrupts or polling is used for communication",
      swaccess: "rw",
      hwaccess: "none",
      fields: [
        { bits: "31:1" },
        { bits: "0",
          name: "intr_enable",
          desc: "If 1 interruts are used, if 0 polling is used"
        }
      ],
    },
    { name: "Length_c111",
      desc: "Lenght of payload + header",
      swaccess: "rw",
      hwaccess: "none",
      fields: [
        { bits: "31:0" }
      ],
    },
    { name: "Message_Header_c111",
      desc: "Defines which commanad the message contains",
      swaccess: "rw",
      hwaccess: "none",
      fields: [
        { bits: "31:28" },
        { bits: "27:18",
          name: "Token",
          desc: "must be same for the msg responses associated to a msg whith the same header"
        },
        { bits: "17:10",
          name: "Protocol_Id",
          desc: "Identifies to which protocol the command belongs to"
        },
        { bits: "9:8",
          name: "Message_Type",
          desc: "can be 0,1,2,3 depending on the kind of msg to be sent"
        },
        { bits: "7:0",
          name: "Message_Id",
          desc: "unique identifier for each command availabe in the protocol pointed by protocol_id"
        }
      ],
    },
    { name: "Message_Payload_1_c111",
      desc: "memory region dedicated to the parameters of the commands and their returns",
      swaccess: "rw",
      hwaccess: "none",
      fields: [
        { bits: "31:0" }
      ],
    },
    { name: "Doorbell_c111",
      desc: "Rapresents the interrupt to be raised towards the platform",
      swaccess: "rw",
      hwaccess: "hro",
      fields: [
        { bits: "31:1",
          name: "Preserve_Mask",
          desc: "These bits must be constant to 0, not used with just one platform and one agent"
        },
        { bits: "0",
          name: "intr",
          desc: "Interrupt bit"
        }
      ],
    },
    { name:  "Completion_Interrupt_c111",
      desc: "Rapresent the interrupt the platform should raise when it finishes to execute the received command",
      swaccess: "rw",
      hwaccess: "hro",
      fields: [
        { bits: "31:1",
          name: "Preserve_Mask",
          desc: "These bits must be constant to 0, not used with just one platform and one agent"
        },
        { bits: "0",
          name: "intr",
          desc: "Interrupt bit"
        }
      ],
    },
    { name: "Reserved_1_c112",
      desc: "Reserved, must be 0",
      swaccess: "rw",
      hwaccess: "none",
      fields: [
        { bits: "31:0" }
      ],
    },
    { name: "Channel_Status_c112",
      desc: "Indicates which entity has access to the Shared Memory",
      swaccess: "rw",
      hwaccess: "none",
      fields: [
        { bits: "31:2" },
        { bits: "1",
          name: "channel_error",
          desc: "Must be 0 in absence of errors"
        },
        { bits: "0",
          name: "channel_free",
          desc: "If 1 the agent own the channel, if 0 the platform own the channel"
        }
      ],
    },
    { name: "Reserved_2_c112",
      desc: "Reserved, implementation defined (32 bits over 64)",
      swaccess: "rw",
      hwaccess: "none",
      fields: [
        { bits: "31:0" }
      ],
    },
    { name: "Reserved_3_c112",
      desc: "Reserved, implementation defined (32 bits over 64)",
      swaccess: "none",
      hwaccess: "none",
      fields: [
        { bits: "31:0" }
      ],
    },
    { name: "Channel_Flags_c112",
      desc: "Defines wheter interrupts or polling is used for communication",
      swaccess: "rw",
      hwaccess: "none",
      fields: [
        { bits: "31:1" },
        { bits: "0",
          name: "intr_enable",
          desc: "If 1 interruts are used, if 0 polling is used"
        }
      ],
    },
    { name: "Length_c112",
      desc: "Lenght of payload + header",
      swaccess: "rw",
      hwaccess: "none",
      fields: [
        { bits: "31:0" }
      ],
    },
    { name: "Message_Header_c112",
      desc: "Defines which commanad the message contains",
      swaccess: "rw",
      hwaccess: "none",
      fields: [
        { bits: "31:28" },
        { bits: "27:18",
          name: "Token",
          desc: "must be same for the msg responses associated to a msg whith the same header"
        },
        { bits: "17:10",
          name: "Protocol_Id",
          desc: "Identifies to which protocol the command belongs to"
        },
        { bits: "9:8",
          name: "Message_Type",
          desc: "can be 0,1,2,3 depending on the kind of msg to be sent"
        },
        { bits: "7:0",
          name: "Message_Id",
          desc: "unique identifier for each command availabe in the protocol pointed by protocol_id"
        }
      ],
    },
    { name: "Message_Payload_1_c112",
      desc: "memory region dedicated to the parameters of the commands and their returns",
      swaccess: "rw",
      hwaccess: "none",
      fields: [
        { bits: "31:0" }
      ],
    },
    { name: "Doorbell_c112",
      desc: "Rapresents the interrupt to be raised towards the platform",
      swaccess: "rw",
      hwaccess: "hro",
      fields: [
        { bits: "31:1",
          name: "Preserve_Mask",
          desc: "These bits must be constant to 0, not used with just one platform and one agent"
        },
        { bits: "0",
          name: "intr",
          desc: "Interrupt bit"
        }
      ],
    },
    { name:  "Completion_Interrupt_c112",
      desc: "Rapresent the interrupt the platform should raise when it finishes to execute the received command",
      swaccess: "rw",
      hwaccess: "hro",
      fields: [
        { bits: "31:1",
          name: "Preserve_Mask",
          desc: "These bits must be constant to 0, not used with just one platform and one agent"
        },
        { bits: "0",
          name: "intr",
          desc: "Interrupt bit"
        }
      ],
    },
    { name: "Reserved_1_c113",
      desc: "Reserved, must be 0",
      swaccess: "rw",
      hwaccess: "none",
      fields: [
        { bits: "31:0" }
      ],
    },
    { name: "Channel_Status_c113",
      desc: "Indicates which entity has access to the Shared Memory",
      swaccess: "rw",
      hwaccess: "none",
      fields: [
        { bits: "31:2" },
        { bits: "1",
          name: "channel_error",
          desc: "Must be 0 in absence of errors"
        },
        { bits: "0",
          name: "channel_free",
          desc: "If 1 the agent own the channel, if 0 the platform own the channel"
        }
      ],
    },
    { name: "Reserved_2_c113",
      desc: "Reserved, implementation defined (32 bits over 64)",
      swaccess: "rw",
      hwaccess: "none",
      fields: [
        { bits: "31:0" }
      ],
    },
    { name: "Reserved_3_c113",
      desc: "Reserved, implementation defined (32 bits over 64)",
      swaccess: "none",
      hwaccess: "none",
      fields: [
        { bits: "31:0" }
      ],
    },
    { name: "Channel_Flags_c113",
      desc: "Defines wheter interrupts or polling is used for communication",
      swaccess: "rw",
      hwaccess: "none",
      fields: [
        { bits: "31:1" },
        { bits: "0",
          name: "intr_enable",
          desc: "If 1 interruts are used, if 0 polling is used"
        }
      ],
    },
    { name: "Length_c113",
      desc: "Lenght of payload + header",
      swaccess: "rw",
      hwaccess: "none",
      fields: [
        { bits: "31:0" }
      ],
    },
    { name: "Message_Header_c113",
      desc: "Defines which commanad the message contains",
      swaccess: "rw",
      hwaccess: "none",
      fields: [
        { bits: "31:28" },
        { bits: "27:18",
          name: "Token",
          desc: "must be same for the msg responses associated to a msg whith the same header"
        },
        { bits: "17:10",
          name: "Protocol_Id",
          desc: "Identifies to which protocol the command belongs to"
        },
        { bits: "9:8",
          name: "Message_Type",
          desc: "can be 0,1,2,3 depending on the kind of msg to be sent"
        },
        { bits: "7:0",
          name: "Message_Id",
          desc: "unique identifier for each command availabe in the protocol pointed by protocol_id"
        }
      ],
    },
    { name: "Message_Payload_1_c113",
      desc: "memory region dedicated to the parameters of the commands and their returns",
      swaccess: "rw",
      hwaccess: "none",
      fields: [
        { bits: "31:0" }
      ],
    },
    { name: "Doorbell_c113",
      desc: "Rapresents the interrupt to be raised towards the platform",
      swaccess: "rw",
      hwaccess: "hro",
      fields: [
        { bits: "31:1",
          name: "Preserve_Mask",
          desc: "These bits must be constant to 0, not used with just one platform and one agent"
        },
        { bits: "0",
          name: "intr",
          desc: "Interrupt bit"
        }
      ],
    },
    { name:  "Completion_Interrupt_c113",
      desc: "Rapresent the interrupt the platform should raise when it finishes to execute the received command",
      swaccess: "rw",
      hwaccess: "hro",
      fields: [
        { bits: "31:1",
          name: "Preserve_Mask",
          desc: "These bits must be constant to 0, not used with just one platform and one agent"
        },
        { bits: "0",
          name: "intr",
          desc: "Interrupt bit"
        }
      ],
    },
    { name: "Reserved_1_c114",
      desc: "Reserved, must be 0",
      swaccess: "rw",
      hwaccess: "none",
      fields: [
        { bits: "31:0" }
      ],
    },
    { name: "Channel_Status_c114",
      desc: "Indicates which entity has access to the Shared Memory",
      swaccess: "rw",
      hwaccess: "none",
      fields: [
        { bits: "31:2" },
        { bits: "1",
          name: "channel_error",
          desc: "Must be 0 in absence of errors"
        },
        { bits: "0",
          name: "channel_free",
          desc: "If 1 the agent own the channel, if 0 the platform own the channel"
        }
      ],
    },
    { name: "Reserved_2_c114",
      desc: "Reserved, implementation defined (32 bits over 64)",
      swaccess: "rw",
      hwaccess: "none",
      fields: [
        { bits: "31:0" }
      ],
    },
    { name: "Reserved_3_c114",
      desc: "Reserved, implementation defined (32 bits over 64)",
      swaccess: "none",
      hwaccess: "none",
      fields: [
        { bits: "31:0" }
      ],
    },
    { name: "Channel_Flags_c114",
      desc: "Defines wheter interrupts or polling is used for communication",
      swaccess: "rw",
      hwaccess: "none",
      fields: [
        { bits: "31:1" },
        { bits: "0",
          name: "intr_enable",
          desc: "If 1 interruts are used, if 0 polling is used"
        }
      ],
    },
    { name: "Length_c114",
      desc: "Lenght of payload + header",
      swaccess: "rw",
      hwaccess: "none",
      fields: [
        { bits: "31:0" }
      ],
    },
    { name: "Message_Header_c114",
      desc: "Defines which commanad the message contains",
      swaccess: "rw",
      hwaccess: "none",
      fields: [
        { bits: "31:28" },
        { bits: "27:18",
          name: "Token",
          desc: "must be same for the msg responses associated to a msg whith the same header"
        },
        { bits: "17:10",
          name: "Protocol_Id",
          desc: "Identifies to which protocol the command belongs to"
        },
        { bits: "9:8",
          name: "Message_Type",
          desc: "can be 0,1,2,3 depending on the kind of msg to be sent"
        },
        { bits: "7:0",
          name: "Message_Id",
          desc: "unique identifier for each command availabe in the protocol pointed by protocol_id"
        }
      ],
    },
    { name: "Message_Payload_1_c114",
      desc: "memory region dedicated to the parameters of the commands and their returns",
      swaccess: "rw",
      hwaccess: "none",
      fields: [
        { bits: "31:0" }
      ],
    },
    { name: "Doorbell_c114",
      desc: "Rapresents the interrupt to be raised towards the platform",
      swaccess: "rw",
      hwaccess: "hro",
      fields: [
        { bits: "31:1",
          name: "Preserve_Mask",
          desc: "These bits must be constant to 0, not used with just one platform and one agent"
        },
        { bits: "0",
          name: "intr",
          desc: "Interrupt bit"
        }
      ],
    },
    { name:  "Completion_Interrupt_c114",
      desc: "Rapresent the interrupt the platform should raise when it finishes to execute the received command",
      swaccess: "rw",
      hwaccess: "hro",
      fields: [
        { bits: "31:1",
          name: "Preserve_Mask",
          desc: "These bits must be constant to 0, not used with just one platform and one agent"
        },
        { bits: "0",
          name: "intr",
          desc: "Interrupt bit"
        }
      ],
    },
    { name: "Reserved_1_c115",
      desc: "Reserved, must be 0",
      swaccess: "rw",
      hwaccess: "none",
      fields: [
        { bits: "31:0" }
      ],
    },
    { name: "Channel_Status_c115",
      desc: "Indicates which entity has access to the Shared Memory",
      swaccess: "rw",
      hwaccess: "none",
      fields: [
        { bits: "31:2" },
        { bits: "1",
          name: "channel_error",
          desc: "Must be 0 in absence of errors"
        },
        { bits: "0",
          name: "channel_free",
          desc: "If 1 the agent own the channel, if 0 the platform own the channel"
        }
      ],
    },
    { name: "Reserved_2_c115",
      desc: "Reserved, implementation defined (32 bits over 64)",
      swaccess: "rw",
      hwaccess: "none",
      fields: [
        { bits: "31:0" }
      ],
    },
    { name: "Reserved_3_c115",
      desc: "Reserved, implementation defined (32 bits over 64)",
      swaccess: "none",
      hwaccess: "none",
      fields: [
        { bits: "31:0" }
      ],
    },
    { name: "Channel_Flags_c115",
      desc: "Defines wheter interrupts or polling is used for communication",
      swaccess: "rw",
      hwaccess: "none",
      fields: [
        { bits: "31:1" },
        { bits: "0",
          name: "intr_enable",
          desc: "If 1 interruts are used, if 0 polling is used"
        }
      ],
    },
    { name: "Length_c115",
      desc: "Lenght of payload + header",
      swaccess: "rw",
      hwaccess: "none",
      fields: [
        { bits: "31:0" }
      ],
    },
    { name: "Message_Header_c115",
      desc: "Defines which commanad the message contains",
      swaccess: "rw",
      hwaccess: "none",
      fields: [
        { bits: "31:28" },
        { bits: "27:18",
          name: "Token",
          desc: "must be same for the msg responses associated to a msg whith the same header"
        },
        { bits: "17:10",
          name: "Protocol_Id",
          desc: "Identifies to which protocol the command belongs to"
        },
        { bits: "9:8",
          name: "Message_Type",
          desc: "can be 0,1,2,3 depending on the kind of msg to be sent"
        },
        { bits: "7:0",
          name: "Message_Id",
          desc: "unique identifier for each command availabe in the protocol pointed by protocol_id"
        }
      ],
    },
    { name: "Message_Payload_1_c115",
      desc: "memory region dedicated to the parameters of the commands and their returns",
      swaccess: "rw",
      hwaccess: "none",
      fields: [
        { bits: "31:0" }
      ],
    },
    { name: "Doorbell_c115",
      desc: "Rapresents the interrupt to be raised towards the platform",
      swaccess: "rw",
      hwaccess: "hro",
      fields: [
        { bits: "31:1",
          name: "Preserve_Mask",
          desc: "These bits must be constant to 0, not used with just one platform and one agent"
        },
        { bits: "0",
          name: "intr",
          desc: "Interrupt bit"
        }
      ],
    },
    { name:  "Completion_Interrupt_c115",
      desc: "Rapresent the interrupt the platform should raise when it finishes to execute the received command",
      swaccess: "rw",
      hwaccess: "hro",
      fields: [
        { bits: "31:1",
          name: "Preserve_Mask",
          desc: "These bits must be constant to 0, not used with just one platform and one agent"
        },
        { bits: "0",
          name: "intr",
          desc: "Interrupt bit"
        }
      ],
    },
    { name: "Reserved_1_c116",
      desc: "Reserved, must be 0",
      swaccess: "rw",
      hwaccess: "none",
      fields: [
        { bits: "31:0" }
      ],
    },
    { name: "Channel_Status_c116",
      desc: "Indicates which entity has access to the Shared Memory",
      swaccess: "rw",
      hwaccess: "none",
      fields: [
        { bits: "31:2" },
        { bits: "1",
          name: "channel_error",
          desc: "Must be 0 in absence of errors"
        },
        { bits: "0",
          name: "channel_free",
          desc: "If 1 the agent own the channel, if 0 the platform own the channel"
        }
      ],
    },
    { name: "Reserved_2_c116",
      desc: "Reserved, implementation defined (32 bits over 64)",
      swaccess: "rw",
      hwaccess: "none",
      fields: [
        { bits: "31:0" }
      ],
    },
    { name: "Reserved_3_c116",
      desc: "Reserved, implementation defined (32 bits over 64)",
      swaccess: "none",
      hwaccess: "none",
      fields: [
        { bits: "31:0" }
      ],
    },
    { name: "Channel_Flags_c116",
      desc: "Defines wheter interrupts or polling is used for communication",
      swaccess: "rw",
      hwaccess: "none",
      fields: [
        { bits: "31:1" },
        { bits: "0",
          name: "intr_enable",
          desc: "If 1 interruts are used, if 0 polling is used"
        }
      ],
    },
    { name: "Length_c116",
      desc: "Lenght of payload + header",
      swaccess: "rw",
      hwaccess: "none",
      fields: [
        { bits: "31:0" }
      ],
    },
    { name: "Message_Header_c116",
      desc: "Defines which commanad the message contains",
      swaccess: "rw",
      hwaccess: "none",
      fields: [
        { bits: "31:28" },
        { bits: "27:18",
          name: "Token",
          desc: "must be same for the msg responses associated to a msg whith the same header"
        },
        { bits: "17:10",
          name: "Protocol_Id",
          desc: "Identifies to which protocol the command belongs to"
        },
        { bits: "9:8",
          name: "Message_Type",
          desc: "can be 0,1,2,3 depending on the kind of msg to be sent"
        },
        { bits: "7:0",
          name: "Message_Id",
          desc: "unique identifier for each command availabe in the protocol pointed by protocol_id"
        }
      ],
    },
    { name: "Message_Payload_1_c116",
      desc: "memory region dedicated to the parameters of the commands and their returns",
      swaccess: "rw",
      hwaccess: "none",
      fields: [
        { bits: "31:0" }
      ],
    },
    { name: "Doorbell_c116",
      desc: "Rapresents the interrupt to be raised towards the platform",
      swaccess: "rw",
      hwaccess: "hro",
      fields: [
        { bits: "31:1",
          name: "Preserve_Mask",
          desc: "These bits must be constant to 0, not used with just one platform and one agent"
        },
        { bits: "0",
          name: "intr",
          desc: "Interrupt bit"
        }
      ],
    },
    { name:  "Completion_Interrupt_c116",
      desc: "Rapresent the interrupt the platform should raise when it finishes to execute the received command",
      swaccess: "rw",
      hwaccess: "hro",
      fields: [
        { bits: "31:1",
          name: "Preserve_Mask",
          desc: "These bits must be constant to 0, not used with just one platform and one agent"
        },
        { bits: "0",
          name: "intr",
          desc: "Interrupt bit"
        }
      ],
    },
    { name: "Reserved_1_c117",
      desc: "Reserved, must be 0",
      swaccess: "rw",
      hwaccess: "none",
      fields: [
        { bits: "31:0" }
      ],
    },
    { name: "Channel_Status_c117",
      desc: "Indicates which entity has access to the Shared Memory",
      swaccess: "rw",
      hwaccess: "none",
      fields: [
        { bits: "31:2" },
        { bits: "1",
          name: "channel_error",
          desc: "Must be 0 in absence of errors"
        },
        { bits: "0",
          name: "channel_free",
          desc: "If 1 the agent own the channel, if 0 the platform own the channel"
        }
      ],
    },
    { name: "Reserved_2_c117",
      desc: "Reserved, implementation defined (32 bits over 64)",
      swaccess: "rw",
      hwaccess: "none",
      fields: [
        { bits: "31:0" }
      ],
    },
    { name: "Reserved_3_c117",
      desc: "Reserved, implementation defined (32 bits over 64)",
      swaccess: "none",
      hwaccess: "none",
      fields: [
        { bits: "31:0" }
      ],
    },
    { name: "Channel_Flags_c117",
      desc: "Defines wheter interrupts or polling is used for communication",
      swaccess: "rw",
      hwaccess: "none",
      fields: [
        { bits: "31:1" },
        { bits: "0",
          name: "intr_enable",
          desc: "If 1 interruts are used, if 0 polling is used"
        }
      ],
    },
    { name: "Length_c117",
      desc: "Lenght of payload + header",
      swaccess: "rw",
      hwaccess: "none",
      fields: [
        { bits: "31:0" }
      ],
    },
    { name: "Message_Header_c117",
      desc: "Defines which commanad the message contains",
      swaccess: "rw",
      hwaccess: "none",
      fields: [
        { bits: "31:28" },
        { bits: "27:18",
          name: "Token",
          desc: "must be same for the msg responses associated to a msg whith the same header"
        },
        { bits: "17:10",
          name: "Protocol_Id",
          desc: "Identifies to which protocol the command belongs to"
        },
        { bits: "9:8",
          name: "Message_Type",
          desc: "can be 0,1,2,3 depending on the kind of msg to be sent"
        },
        { bits: "7:0",
          name: "Message_Id",
          desc: "unique identifier for each command availabe in the protocol pointed by protocol_id"
        }
      ],
    },
    { name: "Message_Payload_1_c117",
      desc: "memory region dedicated to the parameters of the commands and their returns",
      swaccess: "rw",
      hwaccess: "none",
      fields: [
        { bits: "31:0" }
      ],
    },
    { name: "Doorbell_c117",
      desc: "Rapresents the interrupt to be raised towards the platform",
      swaccess: "rw",
      hwaccess: "hro",
      fields: [
        { bits: "31:1",
          name: "Preserve_Mask",
          desc: "These bits must be constant to 0, not used with just one platform and one agent"
        },
        { bits: "0",
          name: "intr",
          desc: "Interrupt bit"
        }
      ],
    },
    { name:  "Completion_Interrupt_c117",
      desc: "Rapresent the interrupt the platform should raise when it finishes to execute the received command",
      swaccess: "rw",
      hwaccess: "hro",
      fields: [
        { bits: "31:1",
          name: "Preserve_Mask",
          desc: "These bits must be constant to 0, not used with just one platform and one agent"
        },
        { bits: "0",
          name: "intr",
          desc: "Interrupt bit"
        }
      ],
    },
    { name: "Reserved_1_c118",
      desc: "Reserved, must be 0",
      swaccess: "rw",
      hwaccess: "none",
      fields: [
        { bits: "31:0" }
      ],
    },
    { name: "Channel_Status_c118",
      desc: "Indicates which entity has access to the Shared Memory",
      swaccess: "rw",
      hwaccess: "none",
      fields: [
        { bits: "31:2" },
        { bits: "1",
          name: "channel_error",
          desc: "Must be 0 in absence of errors"
        },
        { bits: "0",
          name: "channel_free",
          desc: "If 1 the agent own the channel, if 0 the platform own the channel"
        }
      ],
    },
    { name: "Reserved_2_c118",
      desc: "Reserved, implementation defined (32 bits over 64)",
      swaccess: "rw",
      hwaccess: "none",
      fields: [
        { bits: "31:0" }
      ],
    },
    { name: "Reserved_3_c118",
      desc: "Reserved, implementation defined (32 bits over 64)",
      swaccess: "none",
      hwaccess: "none",
      fields: [
        { bits: "31:0" }
      ],
    },
    { name: "Channel_Flags_c118",
      desc: "Defines wheter interrupts or polling is used for communication",
      swaccess: "rw",
      hwaccess: "none",
      fields: [
        { bits: "31:1" },
        { bits: "0",
          name: "intr_enable",
          desc: "If 1 interruts are used, if 0 polling is used"
        }
      ],
    },
    { name: "Length_c118",
      desc: "Lenght of payload + header",
      swaccess: "rw",
      hwaccess: "none",
      fields: [
        { bits: "31:0" }
      ],
    },
    { name: "Message_Header_c118",
      desc: "Defines which commanad the message contains",
      swaccess: "rw",
      hwaccess: "none",
      fields: [
        { bits: "31:28" },
        { bits: "27:18",
          name: "Token",
          desc: "must be same for the msg responses associated to a msg whith the same header"
        },
        { bits: "17:10",
          name: "Protocol_Id",
          desc: "Identifies to which protocol the command belongs to"
        },
        { bits: "9:8",
          name: "Message_Type",
          desc: "can be 0,1,2,3 depending on the kind of msg to be sent"
        },
        { bits: "7:0",
          name: "Message_Id",
          desc: "unique identifier for each command availabe in the protocol pointed by protocol_id"
        }
      ],
    },
    { name: "Message_Payload_1_c118",
      desc: "memory region dedicated to the parameters of the commands and their returns",
      swaccess: "rw",
      hwaccess: "none",
      fields: [
        { bits: "31:0" }
      ],
    },
    { name: "Doorbell_c118",
      desc: "Rapresents the interrupt to be raised towards the platform",
      swaccess: "rw",
      hwaccess: "hro",
      fields: [
        { bits: "31:1",
          name: "Preserve_Mask",
          desc: "These bits must be constant to 0, not used with just one platform and one agent"
        },
        { bits: "0",
          name: "intr",
          desc: "Interrupt bit"
        }
      ],
    },
    { name:  "Completion_Interrupt_c118",
      desc: "Rapresent the interrupt the platform should raise when it finishes to execute the received command",
      swaccess: "rw",
      hwaccess: "hro",
      fields: [
        { bits: "31:1",
          name: "Preserve_Mask",
          desc: "These bits must be constant to 0, not used with just one platform and one agent"
        },
        { bits: "0",
          name: "intr",
          desc: "Interrupt bit"
        }
      ],
    },
    { name: "Reserved_1_c119",
      desc: "Reserved, must be 0",
      swaccess: "rw",
      hwaccess: "none",
      fields: [
        { bits: "31:0" }
      ],
    },
    { name: "Channel_Status_c119",
      desc: "Indicates which entity has access to the Shared Memory",
      swaccess: "rw",
      hwaccess: "none",
      fields: [
        { bits: "31:2" },
        { bits: "1",
          name: "channel_error",
          desc: "Must be 0 in absence of errors"
        },
        { bits: "0",
          name: "channel_free",
          desc: "If 1 the agent own the channel, if 0 the platform own the channel"
        }
      ],
    },
    { name: "Reserved_2_c119",
      desc: "Reserved, implementation defined (32 bits over 64)",
      swaccess: "rw",
      hwaccess: "none",
      fields: [
        { bits: "31:0" }
      ],
    },
    { name: "Reserved_3_c119",
      desc: "Reserved, implementation defined (32 bits over 64)",
      swaccess: "none",
      hwaccess: "none",
      fields: [
        { bits: "31:0" }
      ],
    },
    { name: "Channel_Flags_c119",
      desc: "Defines wheter interrupts or polling is used for communication",
      swaccess: "rw",
      hwaccess: "none",
      fields: [
        { bits: "31:1" },
        { bits: "0",
          name: "intr_enable",
          desc: "If 1 interruts are used, if 0 polling is used"
        }
      ],
    },
    { name: "Length_c119",
      desc: "Lenght of payload + header",
      swaccess: "rw",
      hwaccess: "none",
      fields: [
        { bits: "31:0" }
      ],
    },
    { name: "Message_Header_c119",
      desc: "Defines which commanad the message contains",
      swaccess: "rw",
      hwaccess: "none",
      fields: [
        { bits: "31:28" },
        { bits: "27:18",
          name: "Token",
          desc: "must be same for the msg responses associated to a msg whith the same header"
        },
        { bits: "17:10",
          name: "Protocol_Id",
          desc: "Identifies to which protocol the command belongs to"
        },
        { bits: "9:8",
          name: "Message_Type",
          desc: "can be 0,1,2,3 depending on the kind of msg to be sent"
        },
        { bits: "7:0",
          name: "Message_Id",
          desc: "unique identifier for each command availabe in the protocol pointed by protocol_id"
        }
      ],
    },
    { name: "Message_Payload_1_c119",
      desc: "memory region dedicated to the parameters of the commands and their returns",
      swaccess: "rw",
      hwaccess: "none",
      fields: [
        { bits: "31:0" }
      ],
    },
    { name: "Doorbell_c119",
      desc: "Rapresents the interrupt to be raised towards the platform",
      swaccess: "rw",
      hwaccess: "hro",
      fields: [
        { bits: "31:1",
          name: "Preserve_Mask",
          desc: "These bits must be constant to 0, not used with just one platform and one agent"
        },
        { bits: "0",
          name: "intr",
          desc: "Interrupt bit"
        }
      ],
    },
    { name:  "Completion_Interrupt_c119",
      desc: "Rapresent the interrupt the platform should raise when it finishes to execute the received command",
      swaccess: "rw",
      hwaccess: "hro",
      fields: [
        { bits: "31:1",
          name: "Preserve_Mask",
          desc: "These bits must be constant to 0, not used with just one platform and one agent"
        },
        { bits: "0",
          name: "intr",
          desc: "Interrupt bit"
        }
      ],
    },
    { name: "Reserved_1_c120",
      desc: "Reserved, must be 0",
      swaccess: "rw",
      hwaccess: "none",
      fields: [
        { bits: "31:0" }
      ],
    },
    { name: "Channel_Status_c120",
      desc: "Indicates which entity has access to the Shared Memory",
      swaccess: "rw",
      hwaccess: "none",
      fields: [
        { bits: "31:2" },
        { bits: "1",
          name: "channel_error",
          desc: "Must be 0 in absence of errors"
        },
        { bits: "0",
          name: "channel_free",
          desc: "If 1 the agent own the channel, if 0 the platform own the channel"
        }
      ],
    },
    { name: "Reserved_2_c120",
      desc: "Reserved, implementation defined (32 bits over 64)",
      swaccess: "rw",
      hwaccess: "none",
      fields: [
        { bits: "31:0" }
      ],
    },
    { name: "Reserved_3_c120",
      desc: "Reserved, implementation defined (32 bits over 64)",
      swaccess: "none",
      hwaccess: "none",
      fields: [
        { bits: "31:0" }
      ],
    },
    { name: "Channel_Flags_c120",
      desc: "Defines wheter interrupts or polling is used for communication",
      swaccess: "rw",
      hwaccess: "none",
      fields: [
        { bits: "31:1" },
        { bits: "0",
          name: "intr_enable",
          desc: "If 1 interruts are used, if 0 polling is used"
        }
      ],
    },
    { name: "Length_c120",
      desc: "Lenght of payload + header",
      swaccess: "rw",
      hwaccess: "none",
      fields: [
        { bits: "31:0" }
      ],
    },
    { name: "Message_Header_c120",
      desc: "Defines which commanad the message contains",
      swaccess: "rw",
      hwaccess: "none",
      fields: [
        { bits: "31:28" },
        { bits: "27:18",
          name: "Token",
          desc: "must be same for the msg responses associated to a msg whith the same header"
        },
        { bits: "17:10",
          name: "Protocol_Id",
          desc: "Identifies to which protocol the command belongs to"
        },
        { bits: "9:8",
          name: "Message_Type",
          desc: "can be 0,1,2,3 depending on the kind of msg to be sent"
        },
        { bits: "7:0",
          name: "Message_Id",
          desc: "unique identifier for each command availabe in the protocol pointed by protocol_id"
        }
      ],
    },
    { name: "Message_Payload_1_c120",
      desc: "memory region dedicated to the parameters of the commands and their returns",
      swaccess: "rw",
      hwaccess: "none",
      fields: [
        { bits: "31:0" }
      ],
    },
    { name: "Doorbell_c120",
      desc: "Rapresents the interrupt to be raised towards the platform",
      swaccess: "rw",
      hwaccess: "hro",
      fields: [
        { bits: "31:1",
          name: "Preserve_Mask",
          desc: "These bits must be constant to 0, not used with just one platform and one agent"
        },
        { bits: "0",
          name: "intr",
          desc: "Interrupt bit"
        }
      ],
    },
    { name:  "Completion_Interrupt_c120",
      desc: "Rapresent the interrupt the platform should raise when it finishes to execute the received command",
      swaccess: "rw",
      hwaccess: "hro",
      fields: [
        { bits: "31:1",
          name: "Preserve_Mask",
          desc: "These bits must be constant to 0, not used with just one platform and one agent"
        },
        { bits: "0",
          name: "intr",
          desc: "Interrupt bit"
        }
      ],
    },
    { name: "Reserved_1_c121",
      desc: "Reserved, must be 0",
      swaccess: "rw",
      hwaccess: "none",
      fields: [
        { bits: "31:0" }
      ],
    },
    { name: "Channel_Status_c121",
      desc: "Indicates which entity has access to the Shared Memory",
      swaccess: "rw",
      hwaccess: "none",
      fields: [
        { bits: "31:2" },
        { bits: "1",
          name: "channel_error",
          desc: "Must be 0 in absence of errors"
        },
        { bits: "0",
          name: "channel_free",
          desc: "If 1 the agent own the channel, if 0 the platform own the channel"
        }
      ],
    },
    { name: "Reserved_2_c121",
      desc: "Reserved, implementation defined (32 bits over 64)",
      swaccess: "rw",
      hwaccess: "none",
      fields: [
        { bits: "31:0" }
      ],
    },
    { name: "Reserved_3_c121",
      desc: "Reserved, implementation defined (32 bits over 64)",
      swaccess: "none",
      hwaccess: "none",
      fields: [
        { bits: "31:0" }
      ],
    },
    { name: "Channel_Flags_c121",
      desc: "Defines wheter interrupts or polling is used for communication",
      swaccess: "rw",
      hwaccess: "none",
      fields: [
        { bits: "31:1" },
        { bits: "0",
          name: "intr_enable",
          desc: "If 1 interruts are used, if 0 polling is used"
        }
      ],
    },
    { name: "Length_c121",
      desc: "Lenght of payload + header",
      swaccess: "rw",
      hwaccess: "none",
      fields: [
        { bits: "31:0" }
      ],
    },
    { name: "Message_Header_c121",
      desc: "Defines which commanad the message contains",
      swaccess: "rw",
      hwaccess: "none",
      fields: [
        { bits: "31:28" },
        { bits: "27:18",
          name: "Token",
          desc: "must be same for the msg responses associated to a msg whith the same header"
        },
        { bits: "17:10",
          name: "Protocol_Id",
          desc: "Identifies to which protocol the command belongs to"
        },
        { bits: "9:8",
          name: "Message_Type",
          desc: "can be 0,1,2,3 depending on the kind of msg to be sent"
        },
        { bits: "7:0",
          name: "Message_Id",
          desc: "unique identifier for each command availabe in the protocol pointed by protocol_id"
        }
      ],
    },
    { name: "Message_Payload_1_c121",
      desc: "memory region dedicated to the parameters of the commands and their returns",
      swaccess: "rw",
      hwaccess: "none",
      fields: [
        { bits: "31:0" }
      ],
    },
    { name: "Doorbell_c121",
      desc: "Rapresents the interrupt to be raised towards the platform",
      swaccess: "rw",
      hwaccess: "hro",
      fields: [
        { bits: "31:1",
          name: "Preserve_Mask",
          desc: "These bits must be constant to 0, not used with just one platform and one agent"
        },
        { bits: "0",
          name: "intr",
          desc: "Interrupt bit"
        }
      ],
    },
    { name:  "Completion_Interrupt_c121",
      desc: "Rapresent the interrupt the platform should raise when it finishes to execute the received command",
      swaccess: "rw",
      hwaccess: "hro",
      fields: [
        { bits: "31:1",
          name: "Preserve_Mask",
          desc: "These bits must be constant to 0, not used with just one platform and one agent"
        },
        { bits: "0",
          name: "intr",
          desc: "Interrupt bit"
        }
      ],
    },
    { name: "Reserved_1_c122",
      desc: "Reserved, must be 0",
      swaccess: "rw",
      hwaccess: "none",
      fields: [
        { bits: "31:0" }
      ],
    },
    { name: "Channel_Status_c122",
      desc: "Indicates which entity has access to the Shared Memory",
      swaccess: "rw",
      hwaccess: "none",
      fields: [
        { bits: "31:2" },
        { bits: "1",
          name: "channel_error",
          desc: "Must be 0 in absence of errors"
        },
        { bits: "0",
          name: "channel_free",
          desc: "If 1 the agent own the channel, if 0 the platform own the channel"
        }
      ],
    },
    { name: "Reserved_2_c122",
      desc: "Reserved, implementation defined (32 bits over 64)",
      swaccess: "rw",
      hwaccess: "none",
      fields: [
        { bits: "31:0" }
      ],
    },
    { name: "Reserved_3_c122",
      desc: "Reserved, implementation defined (32 bits over 64)",
      swaccess: "none",
      hwaccess: "none",
      fields: [
        { bits: "31:0" }
      ],
    },
    { name: "Channel_Flags_c122",
      desc: "Defines wheter interrupts or polling is used for communication",
      swaccess: "rw",
      hwaccess: "none",
      fields: [
        { bits: "31:1" },
        { bits: "0",
          name: "intr_enable",
          desc: "If 1 interruts are used, if 0 polling is used"
        }
      ],
    },
    { name: "Length_c122",
      desc: "Lenght of payload + header",
      swaccess: "rw",
      hwaccess: "none",
      fields: [
        { bits: "31:0" }
      ],
    },
    { name: "Message_Header_c122",
      desc: "Defines which commanad the message contains",
      swaccess: "rw",
      hwaccess: "none",
      fields: [
        { bits: "31:28" },
        { bits: "27:18",
          name: "Token",
          desc: "must be same for the msg responses associated to a msg whith the same header"
        },
        { bits: "17:10",
          name: "Protocol_Id",
          desc: "Identifies to which protocol the command belongs to"
        },
        { bits: "9:8",
          name: "Message_Type",
          desc: "can be 0,1,2,3 depending on the kind of msg to be sent"
        },
        { bits: "7:0",
          name: "Message_Id",
          desc: "unique identifier for each command availabe in the protocol pointed by protocol_id"
        }
      ],
    },
    { name: "Message_Payload_1_c122",
      desc: "memory region dedicated to the parameters of the commands and their returns",
      swaccess: "rw",
      hwaccess: "none",
      fields: [
        { bits: "31:0" }
      ],
    },
    { name: "Doorbell_c122",
      desc: "Rapresents the interrupt to be raised towards the platform",
      swaccess: "rw",
      hwaccess: "hro",
      fields: [
        { bits: "31:1",
          name: "Preserve_Mask",
          desc: "These bits must be constant to 0, not used with just one platform and one agent"
        },
        { bits: "0",
          name: "intr",
          desc: "Interrupt bit"
        }
      ],
    },
    { name:  "Completion_Interrupt_c122",
      desc: "Rapresent the interrupt the platform should raise when it finishes to execute the received command",
      swaccess: "rw",
      hwaccess: "hro",
      fields: [
        { bits: "31:1",
          name: "Preserve_Mask",
          desc: "These bits must be constant to 0, not used with just one platform and one agent"
        },
        { bits: "0",
          name: "intr",
          desc: "Interrupt bit"
        }
      ],
    },
    { name: "Reserved_1_c123",
      desc: "Reserved, must be 0",
      swaccess: "rw",
      hwaccess: "none",
      fields: [
        { bits: "31:0" }
      ],
    },
    { name: "Channel_Status_c123",
      desc: "Indicates which entity has access to the Shared Memory",
      swaccess: "rw",
      hwaccess: "none",
      fields: [
        { bits: "31:2" },
        { bits: "1",
          name: "channel_error",
          desc: "Must be 0 in absence of errors"
        },
        { bits: "0",
          name: "channel_free",
          desc: "If 1 the agent own the channel, if 0 the platform own the channel"
        }
      ],
    },
    { name: "Reserved_2_c123",
      desc: "Reserved, implementation defined (32 bits over 64)",
      swaccess: "rw",
      hwaccess: "none",
      fields: [
        { bits: "31:0" }
      ],
    },
    { name: "Reserved_3_c123",
      desc: "Reserved, implementation defined (32 bits over 64)",
      swaccess: "none",
      hwaccess: "none",
      fields: [
        { bits: "31:0" }
      ],
    },
    { name: "Channel_Flags_c123",
      desc: "Defines wheter interrupts or polling is used for communication",
      swaccess: "rw",
      hwaccess: "none",
      fields: [
        { bits: "31:1" },
        { bits: "0",
          name: "intr_enable",
          desc: "If 1 interruts are used, if 0 polling is used"
        }
      ],
    },
    { name: "Length_c123",
      desc: "Lenght of payload + header",
      swaccess: "rw",
      hwaccess: "none",
      fields: [
        { bits: "31:0" }
      ],
    },
    { name: "Message_Header_c123",
      desc: "Defines which commanad the message contains",
      swaccess: "rw",
      hwaccess: "none",
      fields: [
        { bits: "31:28" },
        { bits: "27:18",
          name: "Token",
          desc: "must be same for the msg responses associated to a msg whith the same header"
        },
        { bits: "17:10",
          name: "Protocol_Id",
          desc: "Identifies to which protocol the command belongs to"
        },
        { bits: "9:8",
          name: "Message_Type",
          desc: "can be 0,1,2,3 depending on the kind of msg to be sent"
        },
        { bits: "7:0",
          name: "Message_Id",
          desc: "unique identifier for each command availabe in the protocol pointed by protocol_id"
        }
      ],
    },
    { name: "Message_Payload_1_c123",
      desc: "memory region dedicated to the parameters of the commands and their returns",
      swaccess: "rw",
      hwaccess: "none",
      fields: [
        { bits: "31:0" }
      ],
    },
    { name: "Doorbell_c123",
      desc: "Rapresents the interrupt to be raised towards the platform",
      swaccess: "rw",
      hwaccess: "hro",
      fields: [
        { bits: "31:1",
          name: "Preserve_Mask",
          desc: "These bits must be constant to 0, not used with just one platform and one agent"
        },
        { bits: "0",
          name: "intr",
          desc: "Interrupt bit"
        }
      ],
    },
    { name:  "Completion_Interrupt_c123",
      desc: "Rapresent the interrupt the platform should raise when it finishes to execute the received command",
      swaccess: "rw",
      hwaccess: "hro",
      fields: [
        { bits: "31:1",
          name: "Preserve_Mask",
          desc: "These bits must be constant to 0, not used with just one platform and one agent"
        },
        { bits: "0",
          name: "intr",
          desc: "Interrupt bit"
        }
      ],
    },
    { name: "Reserved_1_c124",
      desc: "Reserved, must be 0",
      swaccess: "rw",
      hwaccess: "none",
      fields: [
        { bits: "31:0" }
      ],
    },
    { name: "Channel_Status_c124",
      desc: "Indicates which entity has access to the Shared Memory",
      swaccess: "rw",
      hwaccess: "none",
      fields: [
        { bits: "31:2" },
        { bits: "1",
          name: "channel_error",
          desc: "Must be 0 in absence of errors"
        },
        { bits: "0",
          name: "channel_free",
          desc: "If 1 the agent own the channel, if 0 the platform own the channel"
        }
      ],
    },
    { name: "Reserved_2_c124",
      desc: "Reserved, implementation defined (32 bits over 64)",
      swaccess: "rw",
      hwaccess: "none",
      fields: [
        { bits: "31:0" }
      ],
    },
    { name: "Reserved_3_c124",
      desc: "Reserved, implementation defined (32 bits over 64)",
      swaccess: "none",
      hwaccess: "none",
      fields: [
        { bits: "31:0" }
      ],
    },
    { name: "Channel_Flags_c124",
      desc: "Defines wheter interrupts or polling is used for communication",
      swaccess: "rw",
      hwaccess: "none",
      fields: [
        { bits: "31:1" },
        { bits: "0",
          name: "intr_enable",
          desc: "If 1 interruts are used, if 0 polling is used"
        }
      ],
    },
    { name: "Length_c124",
      desc: "Lenght of payload + header",
      swaccess: "rw",
      hwaccess: "none",
      fields: [
        { bits: "31:0" }
      ],
    },
    { name: "Message_Header_c124",
      desc: "Defines which commanad the message contains",
      swaccess: "rw",
      hwaccess: "none",
      fields: [
        { bits: "31:28" },
        { bits: "27:18",
          name: "Token",
          desc: "must be same for the msg responses associated to a msg whith the same header"
        },
        { bits: "17:10",
          name: "Protocol_Id",
          desc: "Identifies to which protocol the command belongs to"
        },
        { bits: "9:8",
          name: "Message_Type",
          desc: "can be 0,1,2,3 depending on the kind of msg to be sent"
        },
        { bits: "7:0",
          name: "Message_Id",
          desc: "unique identifier for each command availabe in the protocol pointed by protocol_id"
        }
      ],
    },
    { name: "Message_Payload_1_c124",
      desc: "memory region dedicated to the parameters of the commands and their returns",
      swaccess: "rw",
      hwaccess: "none",
      fields: [
        { bits: "31:0" }
      ],
    },
    { name: "Doorbell_c124",
      desc: "Rapresents the interrupt to be raised towards the platform",
      swaccess: "rw",
      hwaccess: "hro",
      fields: [
        { bits: "31:1",
          name: "Preserve_Mask",
          desc: "These bits must be constant to 0, not used with just one platform and one agent"
        },
        { bits: "0",
          name: "intr",
          desc: "Interrupt bit"
        }
      ],
    },
    { name:  "Completion_Interrupt_c124",
      desc: "Rapresent the interrupt the platform should raise when it finishes to execute the received command",
      swaccess: "rw",
      hwaccess: "hro",
      fields: [
        { bits: "31:1",
          name: "Preserve_Mask",
          desc: "These bits must be constant to 0, not used with just one platform and one agent"
        },
        { bits: "0",
          name: "intr",
          desc: "Interrupt bit"
        }
      ],
    },
    { name: "Reserved_1_c125",
      desc: "Reserved, must be 0",
      swaccess: "rw",
      hwaccess: "none",
      fields: [
        { bits: "31:0" }
      ],
    },
    { name: "Channel_Status_c125",
      desc: "Indicates which entity has access to the Shared Memory",
      swaccess: "rw",
      hwaccess: "none",
      fields: [
        { bits: "31:2" },
        { bits: "1",
          name: "channel_error",
          desc: "Must be 0 in absence of errors"
        },
        { bits: "0",
          name: "channel_free",
          desc: "If 1 the agent own the channel, if 0 the platform own the channel"
        }
      ],
    },
    { name: "Reserved_2_c125",
      desc: "Reserved, implementation defined (32 bits over 64)",
      swaccess: "rw",
      hwaccess: "none",
      fields: [
        { bits: "31:0" }
      ],
    },
    { name: "Reserved_3_c125",
      desc: "Reserved, implementation defined (32 bits over 64)",
      swaccess: "none",
      hwaccess: "none",
      fields: [
        { bits: "31:0" }
      ],
    },
    { name: "Channel_Flags_c125",
      desc: "Defines wheter interrupts or polling is used for communication",
      swaccess: "rw",
      hwaccess: "none",
      fields: [
        { bits: "31:1" },
        { bits: "0",
          name: "intr_enable",
          desc: "If 1 interruts are used, if 0 polling is used"
        }
      ],
    },
    { name: "Length_c125",
      desc: "Lenght of payload + header",
      swaccess: "rw",
      hwaccess: "none",
      fields: [
        { bits: "31:0" }
      ],
    },
    { name: "Message_Header_c125",
      desc: "Defines which commanad the message contains",
      swaccess: "rw",
      hwaccess: "none",
      fields: [
        { bits: "31:28" },
        { bits: "27:18",
          name: "Token",
          desc: "must be same for the msg responses associated to a msg whith the same header"
        },
        { bits: "17:10",
          name: "Protocol_Id",
          desc: "Identifies to which protocol the command belongs to"
        },
        { bits: "9:8",
          name: "Message_Type",
          desc: "can be 0,1,2,3 depending on the kind of msg to be sent"
        },
        { bits: "7:0",
          name: "Message_Id",
          desc: "unique identifier for each command availabe in the protocol pointed by protocol_id"
        }
      ],
    },
    { name: "Message_Payload_1_c125",
      desc: "memory region dedicated to the parameters of the commands and their returns",
      swaccess: "rw",
      hwaccess: "none",
      fields: [
        { bits: "31:0" }
      ],
    },
    { name: "Doorbell_c125",
      desc: "Rapresents the interrupt to be raised towards the platform",
      swaccess: "rw",
      hwaccess: "hro",
      fields: [
        { bits: "31:1",
          name: "Preserve_Mask",
          desc: "These bits must be constant to 0, not used with just one platform and one agent"
        },
        { bits: "0",
          name: "intr",
          desc: "Interrupt bit"
        }
      ],
    },
    { name:  "Completion_Interrupt_c125",
      desc: "Rapresent the interrupt the platform should raise when it finishes to execute the received command",
      swaccess: "rw",
      hwaccess: "hro",
      fields: [
        { bits: "31:1",
          name: "Preserve_Mask",
          desc: "These bits must be constant to 0, not used with just one platform and one agent"
        },
        { bits: "0",
          name: "intr",
          desc: "Interrupt bit"
        }
      ],
    },
    { name: "Reserved_1_c126",
      desc: "Reserved, must be 0",
      swaccess: "rw",
      hwaccess: "none",
      fields: [
        { bits: "31:0" }
      ],
    },
    { name: "Channel_Status_c126",
      desc: "Indicates which entity has access to the Shared Memory",
      swaccess: "rw",
      hwaccess: "none",
      fields: [
        { bits: "31:2" },
        { bits: "1",
          name: "channel_error",
          desc: "Must be 0 in absence of errors"
        },
        { bits: "0",
          name: "channel_free",
          desc: "If 1 the agent own the channel, if 0 the platform own the channel"
        }
      ],
    },
    { name: "Reserved_2_c126",
      desc: "Reserved, implementation defined (32 bits over 64)",
      swaccess: "rw",
      hwaccess: "none",
      fields: [
        { bits: "31:0" }
      ],
    },
    { name: "Reserved_3_c126",
      desc: "Reserved, implementation defined (32 bits over 64)",
      swaccess: "none",
      hwaccess: "none",
      fields: [
        { bits: "31:0" }
      ],
    },
    { name: "Channel_Flags_c126",
      desc: "Defines wheter interrupts or polling is used for communication",
      swaccess: "rw",
      hwaccess: "none",
      fields: [
        { bits: "31:1" },
        { bits: "0",
          name: "intr_enable",
          desc: "If 1 interruts are used, if 0 polling is used"
        }
      ],
    },
    { name: "Length_c126",
      desc: "Lenght of payload + header",
      swaccess: "rw",
      hwaccess: "none",
      fields: [
        { bits: "31:0" }
      ],
    },
    { name: "Message_Header_c126",
      desc: "Defines which commanad the message contains",
      swaccess: "rw",
      hwaccess: "none",
      fields: [
        { bits: "31:28" },
        { bits: "27:18",
          name: "Token",
          desc: "must be same for the msg responses associated to a msg whith the same header"
        },
        { bits: "17:10",
          name: "Protocol_Id",
          desc: "Identifies to which protocol the command belongs to"
        },
        { bits: "9:8",
          name: "Message_Type",
          desc: "can be 0,1,2,3 depending on the kind of msg to be sent"
        },
        { bits: "7:0",
          name: "Message_Id",
          desc: "unique identifier for each command availabe in the protocol pointed by protocol_id"
        }
      ],
    },
    { name: "Message_Payload_1_c126",
      desc: "memory region dedicated to the parameters of the commands and their returns",
      swaccess: "rw",
      hwaccess: "none",
      fields: [
        { bits: "31:0" }
      ],
    },
    { name: "Doorbell_c126",
      desc: "Rapresents the interrupt to be raised towards the platform",
      swaccess: "rw",
      hwaccess: "hro",
      fields: [
        { bits: "31:1",
          name: "Preserve_Mask",
          desc: "These bits must be constant to 0, not used with just one platform and one agent"
        },
        { bits: "0",
          name: "intr",
          desc: "Interrupt bit"
        }
      ],
    },
    { name:  "Completion_Interrupt_c126",
      desc: "Rapresent the interrupt the platform should raise when it finishes to execute the received command",
      swaccess: "rw",
      hwaccess: "hro",
      fields: [
        { bits: "31:1",
          name: "Preserve_Mask",
          desc: "These bits must be constant to 0, not used with just one platform and one agent"
        },
        { bits: "0",
          name: "intr",
          desc: "Interrupt bit"
        }
      ],
    },
    { name: "Reserved_1_c127",
      desc: "Reserved, must be 0",
      swaccess: "rw",
      hwaccess: "none",
      fields: [
        { bits: "31:0" }
      ],
    },
    { name: "Channel_Status_c127",
      desc: "Indicates which entity has access to the Shared Memory",
      swaccess: "rw",
      hwaccess: "none",
      fields: [
        { bits: "31:2" },
        { bits: "1",
          name: "channel_error",
          desc: "Must be 0 in absence of errors"
        },
        { bits: "0",
          name: "channel_free",
          desc: "If 1 the agent own the channel, if 0 the platform own the channel"
        }
      ],
    },
    { name: "Reserved_2_c127",
      desc: "Reserved, implementation defined (32 bits over 64)",
      swaccess: "rw",
      hwaccess: "none",
      fields: [
        { bits: "31:0" }
      ],
    },
    { name: "Reserved_3_c127",
      desc: "Reserved, implementation defined (32 bits over 64)",
      swaccess: "none",
      hwaccess: "none",
      fields: [
        { bits: "31:0" }
      ],
    },
    { name: "Channel_Flags_c127",
      desc: "Defines wheter interrupts or polling is used for communication",
      swaccess: "rw",
      hwaccess: "none",
      fields: [
        { bits: "31:1" },
        { bits: "0",
          name: "intr_enable",
          desc: "If 1 interruts are used, if 0 polling is used"
        }
      ],
    },
    { name: "Length_c127",
      desc: "Lenght of payload + header",
      swaccess: "rw",
      hwaccess: "none",
      fields: [
        { bits: "31:0" }
      ],
    },
    { name: "Message_Header_c127",
      desc: "Defines which commanad the message contains",
      swaccess: "rw",
      hwaccess: "none",
      fields: [
        { bits: "31:28" },
        { bits: "27:18",
          name: "Token",
          desc: "must be same for the msg responses associated to a msg whith the same header"
        },
        { bits: "17:10",
          name: "Protocol_Id",
          desc: "Identifies to which protocol the command belongs to"
        },
        { bits: "9:8",
          name: "Message_Type",
          desc: "can be 0,1,2,3 depending on the kind of msg to be sent"
        },
        { bits: "7:0",
          name: "Message_Id",
          desc: "unique identifier for each command availabe in the protocol pointed by protocol_id"
        }
      ],
    },
    { name: "Message_Payload_1_c127",
      desc: "memory region dedicated to the parameters of the commands and their returns",
      swaccess: "rw",
      hwaccess: "none",
      fields: [
        { bits: "31:0" }
      ],
    },
    { name: "Doorbell_c127",
      desc: "Rapresents the interrupt to be raised towards the platform",
      swaccess: "rw",
      hwaccess: "hro",
      fields: [
        { bits: "31:1",
          name: "Preserve_Mask",
          desc: "These bits must be constant to 0, not used with just one platform and one agent"
        },
        { bits: "0",
          name: "intr",
          desc: "Interrupt bit"
        }
      ],
    },
    { name:  "Completion_Interrupt_c127",
      desc: "Rapresent the interrupt the platform should raise when it finishes to execute the received command",
      swaccess: "rw",
      hwaccess: "hro",
      fields: [
        { bits: "31:1",
          name: "Preserve_Mask",
          desc: "These bits must be constant to 0, not used with just one platform and one agent"
        },
        { bits: "0",
          name: "intr",
          desc: "Interrupt bit"
        }
      ],
    },
    { name: "Reserved_1_c128",
      desc: "Reserved, must be 0",
      swaccess: "rw",
      hwaccess: "none",
      fields: [
        { bits: "31:0" }
      ],
    },
    { name: "Channel_Status_c128",
      desc: "Indicates which entity has access to the Shared Memory",
      swaccess: "rw",
      hwaccess: "none",
      fields: [
        { bits: "31:2" },
        { bits: "1",
          name: "channel_error",
          desc: "Must be 0 in absence of errors"
        },
        { bits: "0",
          name: "channel_free",
          desc: "If 1 the agent own the channel, if 0 the platform own the channel"
        }
      ],
    },
    { name: "Reserved_2_c128",
      desc: "Reserved, implementation defined (32 bits over 64)",
      swaccess: "rw",
      hwaccess: "none",
      fields: [
        { bits: "31:0" }
      ],
    },
    { name: "Reserved_3_c128",
      desc: "Reserved, implementation defined (32 bits over 64)",
      swaccess: "none",
      hwaccess: "none",
      fields: [
        { bits: "31:0" }
      ],
    },
    { name: "Channel_Flags_c128",
      desc: "Defines wheter interrupts or polling is used for communication",
      swaccess: "rw",
      hwaccess: "none",
      fields: [
        { bits: "31:1" },
        { bits: "0",
          name: "intr_enable",
          desc: "If 1 interruts are used, if 0 polling is used"
        }
      ],
    },
    { name: "Length_c128",
      desc: "Lenght of payload + header",
      swaccess: "rw",
      hwaccess: "none",
      fields: [
        { bits: "31:0" }
      ],
    },
    { name: "Message_Header_c128",
      desc: "Defines which commanad the message contains",
      swaccess: "rw",
      hwaccess: "none",
      fields: [
        { bits: "31:28" },
        { bits: "27:18",
          name: "Token",
          desc: "must be same for the msg responses associated to a msg whith the same header"
        },
        { bits: "17:10",
          name: "Protocol_Id",
          desc: "Identifies to which protocol the command belongs to"
        },
        { bits: "9:8",
          name: "Message_Type",
          desc: "can be 0,1,2,3 depending on the kind of msg to be sent"
        },
        { bits: "7:0",
          name: "Message_Id",
          desc: "unique identifier for each command availabe in the protocol pointed by protocol_id"
        }
      ],
    },
    { name: "Message_Payload_1_c128",
      desc: "memory region dedicated to the parameters of the commands and their returns",
      swaccess: "rw",
      hwaccess: "none",
      fields: [
        { bits: "31:0" }
      ],
    },
    { name: "Doorbell_c128",
      desc: "Rapresents the interrupt to be raised towards the platform",
      swaccess: "rw",
      hwaccess: "hro",
      fields: [
        { bits: "31:1",
          name: "Preserve_Mask",
          desc: "These bits must be constant to 0, not used with just one platform and one agent"
        },
        { bits: "0",
          name: "intr",
          desc: "Interrupt bit"
        }
      ],
    },
    { name:  "Completion_Interrupt_c128",
      desc: "Rapresent the interrupt the platform should raise when it finishes to execute the received command",
      swaccess: "rw",
      hwaccess: "hro",
      fields: [
        { bits: "31:1",
          name: "Preserve_Mask",
          desc: "These bits must be constant to 0, not used with just one platform and one agent"
        },
        { bits: "0",
          name: "intr",
          desc: "Interrupt bit"
        }
      ],
    },
    { name: "Reserved_1_c129",
      desc: "Reserved, must be 0",
      swaccess: "rw",
      hwaccess: "none",
      fields: [
        { bits: "31:0" }
      ],
    },
    { name: "Channel_Status_c129",
      desc: "Indicates which entity has access to the Shared Memory",
      swaccess: "rw",
      hwaccess: "none",
      fields: [
        { bits: "31:2" },
        { bits: "1",
          name: "channel_error",
          desc: "Must be 0 in absence of errors"
        },
        { bits: "0",
          name: "channel_free",
          desc: "If 1 the agent own the channel, if 0 the platform own the channel"
        }
      ],
    },
    { name: "Reserved_2_c129",
      desc: "Reserved, implementation defined (32 bits over 64)",
      swaccess: "rw",
      hwaccess: "none",
      fields: [
        { bits: "31:0" }
      ],
    },
    { name: "Reserved_3_c129",
      desc: "Reserved, implementation defined (32 bits over 64)",
      swaccess: "none",
      hwaccess: "none",
      fields: [
        { bits: "31:0" }
      ],
    },
    { name: "Channel_Flags_c129",
      desc: "Defines wheter interrupts or polling is used for communication",
      swaccess: "rw",
      hwaccess: "none",
      fields: [
        { bits: "31:1" },
        { bits: "0",
          name: "intr_enable",
          desc: "If 1 interruts are used, if 0 polling is used"
        }
      ],
    },
    { name: "Length_c129",
      desc: "Lenght of payload + header",
      swaccess: "rw",
      hwaccess: "none",
      fields: [
        { bits: "31:0" }
      ],
    },
    { name: "Message_Header_c129",
      desc: "Defines which commanad the message contains",
      swaccess: "rw",
      hwaccess: "none",
      fields: [
        { bits: "31:28" },
        { bits: "27:18",
          name: "Token",
          desc: "must be same for the msg responses associated to a msg whith the same header"
        },
        { bits: "17:10",
          name: "Protocol_Id",
          desc: "Identifies to which protocol the command belongs to"
        },
        { bits: "9:8",
          name: "Message_Type",
          desc: "can be 0,1,2,3 depending on the kind of msg to be sent"
        },
        { bits: "7:0",
          name: "Message_Id",
          desc: "unique identifier for each command availabe in the protocol pointed by protocol_id"
        }
      ],
    },
    { name: "Message_Payload_1_c129",
      desc: "memory region dedicated to the parameters of the commands and their returns",
      swaccess: "rw",
      hwaccess: "none",
      fields: [
        { bits: "31:0" }
      ],
    },
    { name: "Doorbell_c129",
      desc: "Rapresents the interrupt to be raised towards the platform",
      swaccess: "rw",
      hwaccess: "hro",
      fields: [
        { bits: "31:1",
          name: "Preserve_Mask",
          desc: "These bits must be constant to 0, not used with just one platform and one agent"
        },
        { bits: "0",
          name: "intr",
          desc: "Interrupt bit"
        }
      ],
    },
    { name:  "Completion_Interrupt_c129",
      desc: "Rapresent the interrupt the platform should raise when it finishes to execute the received command",
      swaccess: "rw",
      hwaccess: "hro",
      fields: [
        { bits: "31:1",
          name: "Preserve_Mask",
          desc: "These bits must be constant to 0, not used with just one platform and one agent"
        },
        { bits: "0",
          name: "intr",
          desc: "Interrupt bit"
        }
      ],
    },
    { name: "Reserved_1_c130",
      desc: "Reserved, must be 0",
      swaccess: "rw",
      hwaccess: "none",
      fields: [
        { bits: "31:0" }
      ],
    },
    { name: "Channel_Status_c130",
      desc: "Indicates which entity has access to the Shared Memory",
      swaccess: "rw",
      hwaccess: "none",
      fields: [
        { bits: "31:2" },
        { bits: "1",
          name: "channel_error",
          desc: "Must be 0 in absence of errors"
        },
        { bits: "0",
          name: "channel_free",
          desc: "If 1 the agent own the channel, if 0 the platform own the channel"
        }
      ],
    },
    { name: "Reserved_2_c130",
      desc: "Reserved, implementation defined (32 bits over 64)",
      swaccess: "rw",
      hwaccess: "none",
      fields: [
        { bits: "31:0" }
      ],
    },
    { name: "Reserved_3_c130",
      desc: "Reserved, implementation defined (32 bits over 64)",
      swaccess: "none",
      hwaccess: "none",
      fields: [
        { bits: "31:0" }
      ],
    },
    { name: "Channel_Flags_c130",
      desc: "Defines wheter interrupts or polling is used for communication",
      swaccess: "rw",
      hwaccess: "none",
      fields: [
        { bits: "31:1" },
        { bits: "0",
          name: "intr_enable",
          desc: "If 1 interruts are used, if 0 polling is used"
        }
      ],
    },
    { name: "Length_c130",
      desc: "Lenght of payload + header",
      swaccess: "rw",
      hwaccess: "none",
      fields: [
        { bits: "31:0" }
      ],
    },
    { name: "Message_Header_c130",
      desc: "Defines which commanad the message contains",
      swaccess: "rw",
      hwaccess: "none",
      fields: [
        { bits: "31:28" },
        { bits: "27:18",
          name: "Token",
          desc: "must be same for the msg responses associated to a msg whith the same header"
        },
        { bits: "17:10",
          name: "Protocol_Id",
          desc: "Identifies to which protocol the command belongs to"
        },
        { bits: "9:8",
          name: "Message_Type",
          desc: "can be 0,1,2,3 depending on the kind of msg to be sent"
        },
        { bits: "7:0",
          name: "Message_Id",
          desc: "unique identifier for each command availabe in the protocol pointed by protocol_id"
        }
      ],
    },
    { name: "Message_Payload_1_c130",
      desc: "memory region dedicated to the parameters of the commands and their returns",
      swaccess: "rw",
      hwaccess: "none",
      fields: [
        { bits: "31:0" }
      ],
    },
    { name: "Doorbell_c130",
      desc: "Rapresents the interrupt to be raised towards the platform",
      swaccess: "rw",
      hwaccess: "hro",
      fields: [
        { bits: "31:1",
          name: "Preserve_Mask",
          desc: "These bits must be constant to 0, not used with just one platform and one agent"
        },
        { bits: "0",
          name: "intr",
          desc: "Interrupt bit"
        }
      ],
    },
    { name:  "Completion_Interrupt_c130",
      desc: "Rapresent the interrupt the platform should raise when it finishes to execute the received command",
      swaccess: "rw",
      hwaccess: "hro",
      fields: [
        { bits: "31:1",
          name: "Preserve_Mask",
          desc: "These bits must be constant to 0, not used with just one platform and one agent"
        },
        { bits: "0",
          name: "intr",
          desc: "Interrupt bit"
        }
      ],
    },
    { name: "Reserved_1_c131",
      desc: "Reserved, must be 0",
      swaccess: "rw",
      hwaccess: "none",
      fields: [
        { bits: "31:0" }
      ],
    },
    { name: "Channel_Status_c131",
      desc: "Indicates which entity has access to the Shared Memory",
      swaccess: "rw",
      hwaccess: "none",
      fields: [
        { bits: "31:2" },
        { bits: "1",
          name: "channel_error",
          desc: "Must be 0 in absence of errors"
        },
        { bits: "0",
          name: "channel_free",
          desc: "If 1 the agent own the channel, if 0 the platform own the channel"
        }
      ],
    },
    { name: "Reserved_2_c131",
      desc: "Reserved, implementation defined (32 bits over 64)",
      swaccess: "rw",
      hwaccess: "none",
      fields: [
        { bits: "31:0" }
      ],
    },
    { name: "Reserved_3_c131",
      desc: "Reserved, implementation defined (32 bits over 64)",
      swaccess: "none",
      hwaccess: "none",
      fields: [
        { bits: "31:0" }
      ],
    },
    { name: "Channel_Flags_c131",
      desc: "Defines wheter interrupts or polling is used for communication",
      swaccess: "rw",
      hwaccess: "none",
      fields: [
        { bits: "31:1" },
        { bits: "0",
          name: "intr_enable",
          desc: "If 1 interruts are used, if 0 polling is used"
        }
      ],
    },
    { name: "Length_c131",
      desc: "Lenght of payload + header",
      swaccess: "rw",
      hwaccess: "none",
      fields: [
        { bits: "31:0" }
      ],
    },
    { name: "Message_Header_c131",
      desc: "Defines which commanad the message contains",
      swaccess: "rw",
      hwaccess: "none",
      fields: [
        { bits: "31:28" },
        { bits: "27:18",
          name: "Token",
          desc: "must be same for the msg responses associated to a msg whith the same header"
        },
        { bits: "17:10",
          name: "Protocol_Id",
          desc: "Identifies to which protocol the command belongs to"
        },
        { bits: "9:8",
          name: "Message_Type",
          desc: "can be 0,1,2,3 depending on the kind of msg to be sent"
        },
        { bits: "7:0",
          name: "Message_Id",
          desc: "unique identifier for each command availabe in the protocol pointed by protocol_id"
        }
      ],
    },
    { name: "Message_Payload_1_c131",
      desc: "memory region dedicated to the parameters of the commands and their returns",
      swaccess: "rw",
      hwaccess: "none",
      fields: [
        { bits: "31:0" }
      ],
    },
    { name: "Doorbell_c131",
      desc: "Rapresents the interrupt to be raised towards the platform",
      swaccess: "rw",
      hwaccess: "hro",
      fields: [
        { bits: "31:1",
          name: "Preserve_Mask",
          desc: "These bits must be constant to 0, not used with just one platform and one agent"
        },
        { bits: "0",
          name: "intr",
          desc: "Interrupt bit"
        }
      ],
    },
    { name:  "Completion_Interrupt_c131",
      desc: "Rapresent the interrupt the platform should raise when it finishes to execute the received command",
      swaccess: "rw",
      hwaccess: "hro",
      fields: [
        { bits: "31:1",
          name: "Preserve_Mask",
          desc: "These bits must be constant to 0, not used with just one platform and one agent"
        },
        { bits: "0",
          name: "intr",
          desc: "Interrupt bit"
        }
      ],
    },
    { name: "Reserved_1_c132",
      desc: "Reserved, must be 0",
      swaccess: "rw",
      hwaccess: "none",
      fields: [
        { bits: "31:0" }
      ],
    },
    { name: "Channel_Status_c132",
      desc: "Indicates which entity has access to the Shared Memory",
      swaccess: "rw",
      hwaccess: "none",
      fields: [
        { bits: "31:2" },
        { bits: "1",
          name: "channel_error",
          desc: "Must be 0 in absence of errors"
        },
        { bits: "0",
          name: "channel_free",
          desc: "If 1 the agent own the channel, if 0 the platform own the channel"
        }
      ],
    },
    { name: "Reserved_2_c132",
      desc: "Reserved, implementation defined (32 bits over 64)",
      swaccess: "rw",
      hwaccess: "none",
      fields: [
        { bits: "31:0" }
      ],
    },
    { name: "Reserved_3_c132",
      desc: "Reserved, implementation defined (32 bits over 64)",
      swaccess: "none",
      hwaccess: "none",
      fields: [
        { bits: "31:0" }
      ],
    },
    { name: "Channel_Flags_c132",
      desc: "Defines wheter interrupts or polling is used for communication",
      swaccess: "rw",
      hwaccess: "none",
      fields: [
        { bits: "31:1" },
        { bits: "0",
          name: "intr_enable",
          desc: "If 1 interruts are used, if 0 polling is used"
        }
      ],
    },
    { name: "Length_c132",
      desc: "Lenght of payload + header",
      swaccess: "rw",
      hwaccess: "none",
      fields: [
        { bits: "31:0" }
      ],
    },
    { name: "Message_Header_c132",
      desc: "Defines which commanad the message contains",
      swaccess: "rw",
      hwaccess: "none",
      fields: [
        { bits: "31:28" },
        { bits: "27:18",
          name: "Token",
          desc: "must be same for the msg responses associated to a msg whith the same header"
        },
        { bits: "17:10",
          name: "Protocol_Id",
          desc: "Identifies to which protocol the command belongs to"
        },
        { bits: "9:8",
          name: "Message_Type",
          desc: "can be 0,1,2,3 depending on the kind of msg to be sent"
        },
        { bits: "7:0",
          name: "Message_Id",
          desc: "unique identifier for each command availabe in the protocol pointed by protocol_id"
        }
      ],
    },
    { name: "Message_Payload_1_c132",
      desc: "memory region dedicated to the parameters of the commands and their returns",
      swaccess: "rw",
      hwaccess: "none",
      fields: [
        { bits: "31:0" }
      ],
    },
    { name: "Doorbell_c132",
      desc: "Rapresents the interrupt to be raised towards the platform",
      swaccess: "rw",
      hwaccess: "hro",
      fields: [
        { bits: "31:1",
          name: "Preserve_Mask",
          desc: "These bits must be constant to 0, not used with just one platform and one agent"
        },
        { bits: "0",
          name: "intr",
          desc: "Interrupt bit"
        }
      ],
    },
    { name:  "Completion_Interrupt_c132",
      desc: "Rapresent the interrupt the platform should raise when it finishes to execute the received command",
      swaccess: "rw",
      hwaccess: "hro",
      fields: [
        { bits: "31:1",
          name: "Preserve_Mask",
          desc: "These bits must be constant to 0, not used with just one platform and one agent"
        },
        { bits: "0",
          name: "intr",
          desc: "Interrupt bit"
        }
      ],
    },
    { name: "Reserved_1_c133",
      desc: "Reserved, must be 0",
      swaccess: "rw",
      hwaccess: "none",
      fields: [
        { bits: "31:0" }
      ],
    },
    { name: "Channel_Status_c133",
      desc: "Indicates which entity has access to the Shared Memory",
      swaccess: "rw",
      hwaccess: "none",
      fields: [
        { bits: "31:2" },
        { bits: "1",
          name: "channel_error",
          desc: "Must be 0 in absence of errors"
        },
        { bits: "0",
          name: "channel_free",
          desc: "If 1 the agent own the channel, if 0 the platform own the channel"
        }
      ],
    },
    { name: "Reserved_2_c133",
      desc: "Reserved, implementation defined (32 bits over 64)",
      swaccess: "rw",
      hwaccess: "none",
      fields: [
        { bits: "31:0" }
      ],
    },
    { name: "Reserved_3_c133",
      desc: "Reserved, implementation defined (32 bits over 64)",
      swaccess: "none",
      hwaccess: "none",
      fields: [
        { bits: "31:0" }
      ],
    },
    { name: "Channel_Flags_c133",
      desc: "Defines wheter interrupts or polling is used for communication",
      swaccess: "rw",
      hwaccess: "none",
      fields: [
        { bits: "31:1" },
        { bits: "0",
          name: "intr_enable",
          desc: "If 1 interruts are used, if 0 polling is used"
        }
      ],
    },
    { name: "Length_c133",
      desc: "Lenght of payload + header",
      swaccess: "rw",
      hwaccess: "none",
      fields: [
        { bits: "31:0" }
      ],
    },
    { name: "Message_Header_c133",
      desc: "Defines which commanad the message contains",
      swaccess: "rw",
      hwaccess: "none",
      fields: [
        { bits: "31:28" },
        { bits: "27:18",
          name: "Token",
          desc: "must be same for the msg responses associated to a msg whith the same header"
        },
        { bits: "17:10",
          name: "Protocol_Id",
          desc: "Identifies to which protocol the command belongs to"
        },
        { bits: "9:8",
          name: "Message_Type",
          desc: "can be 0,1,2,3 depending on the kind of msg to be sent"
        },
        { bits: "7:0",
          name: "Message_Id",
          desc: "unique identifier for each command availabe in the protocol pointed by protocol_id"
        }
      ],
    },
    { name: "Message_Payload_1_c133",
      desc: "memory region dedicated to the parameters of the commands and their returns",
      swaccess: "rw",
      hwaccess: "none",
      fields: [
        { bits: "31:0" }
      ],
    },
    { name: "Doorbell_c133",
      desc: "Rapresents the interrupt to be raised towards the platform",
      swaccess: "rw",
      hwaccess: "hro",
      fields: [
        { bits: "31:1",
          name: "Preserve_Mask",
          desc: "These bits must be constant to 0, not used with just one platform and one agent"
        },
        { bits: "0",
          name: "intr",
          desc: "Interrupt bit"
        }
      ],
    },
    { name:  "Completion_Interrupt_c133",
      desc: "Rapresent the interrupt the platform should raise when it finishes to execute the received command",
      swaccess: "rw",
      hwaccess: "hro",
      fields: [
        { bits: "31:1",
          name: "Preserve_Mask",
          desc: "These bits must be constant to 0, not used with just one platform and one agent"
        },
        { bits: "0",
          name: "intr",
          desc: "Interrupt bit"
        }
      ],
    },
    { name: "Reserved_1_c134",
      desc: "Reserved, must be 0",
      swaccess: "rw",
      hwaccess: "none",
      fields: [
        { bits: "31:0" }
      ],
    },
    { name: "Channel_Status_c134",
      desc: "Indicates which entity has access to the Shared Memory",
      swaccess: "rw",
      hwaccess: "none",
      fields: [
        { bits: "31:2" },
        { bits: "1",
          name: "channel_error",
          desc: "Must be 0 in absence of errors"
        },
        { bits: "0",
          name: "channel_free",
          desc: "If 1 the agent own the channel, if 0 the platform own the channel"
        }
      ],
    },
    { name: "Reserved_2_c134",
      desc: "Reserved, implementation defined (32 bits over 64)",
      swaccess: "rw",
      hwaccess: "none",
      fields: [
        { bits: "31:0" }
      ],
    },
    { name: "Reserved_3_c134",
      desc: "Reserved, implementation defined (32 bits over 64)",
      swaccess: "none",
      hwaccess: "none",
      fields: [
        { bits: "31:0" }
      ],
    },
    { name: "Channel_Flags_c134",
      desc: "Defines wheter interrupts or polling is used for communication",
      swaccess: "rw",
      hwaccess: "none",
      fields: [
        { bits: "31:1" },
        { bits: "0",
          name: "intr_enable",
          desc: "If 1 interruts are used, if 0 polling is used"
        }
      ],
    },
    { name: "Length_c134",
      desc: "Lenght of payload + header",
      swaccess: "rw",
      hwaccess: "none",
      fields: [
        { bits: "31:0" }
      ],
    },
    { name: "Message_Header_c134",
      desc: "Defines which commanad the message contains",
      swaccess: "rw",
      hwaccess: "none",
      fields: [
        { bits: "31:28" },
        { bits: "27:18",
          name: "Token",
          desc: "must be same for the msg responses associated to a msg whith the same header"
        },
        { bits: "17:10",
          name: "Protocol_Id",
          desc: "Identifies to which protocol the command belongs to"
        },
        { bits: "9:8",
          name: "Message_Type",
          desc: "can be 0,1,2,3 depending on the kind of msg to be sent"
        },
        { bits: "7:0",
          name: "Message_Id",
          desc: "unique identifier for each command availabe in the protocol pointed by protocol_id"
        }
      ],
    },
    { name: "Message_Payload_1_c134",
      desc: "memory region dedicated to the parameters of the commands and their returns",
      swaccess: "rw",
      hwaccess: "none",
      fields: [
        { bits: "31:0" }
      ],
    },
    { name: "Doorbell_c134",
      desc: "Rapresents the interrupt to be raised towards the platform",
      swaccess: "rw",
      hwaccess: "hro",
      fields: [
        { bits: "31:1",
          name: "Preserve_Mask",
          desc: "These bits must be constant to 0, not used with just one platform and one agent"
        },
        { bits: "0",
          name: "intr",
          desc: "Interrupt bit"
        }
      ],
    },
    { name:  "Completion_Interrupt_c134",
      desc: "Rapresent the interrupt the platform should raise when it finishes to execute the received command",
      swaccess: "rw",
      hwaccess: "hro",
      fields: [
        { bits: "31:1",
          name: "Preserve_Mask",
          desc: "These bits must be constant to 0, not used with just one platform and one agent"
        },
        { bits: "0",
          name: "intr",
          desc: "Interrupt bit"
        }
      ],
    },
    { name: "Reserved_1_c135",
      desc: "Reserved, must be 0",
      swaccess: "rw",
      hwaccess: "none",
      fields: [
        { bits: "31:0" }
      ],
    },
    { name: "Channel_Status_c135",
      desc: "Indicates which entity has access to the Shared Memory",
      swaccess: "rw",
      hwaccess: "none",
      fields: [
        { bits: "31:2" },
        { bits: "1",
          name: "channel_error",
          desc: "Must be 0 in absence of errors"
        },
        { bits: "0",
          name: "channel_free",
          desc: "If 1 the agent own the channel, if 0 the platform own the channel"
        }
      ],
    },
    { name: "Reserved_2_c135",
      desc: "Reserved, implementation defined (32 bits over 64)",
      swaccess: "rw",
      hwaccess: "none",
      fields: [
        { bits: "31:0" }
      ],
    },
    { name: "Reserved_3_c135",
      desc: "Reserved, implementation defined (32 bits over 64)",
      swaccess: "none",
      hwaccess: "none",
      fields: [
        { bits: "31:0" }
      ],
    },
    { name: "Channel_Flags_c135",
      desc: "Defines wheter interrupts or polling is used for communication",
      swaccess: "rw",
      hwaccess: "none",
      fields: [
        { bits: "31:1" },
        { bits: "0",
          name: "intr_enable",
          desc: "If 1 interruts are used, if 0 polling is used"
        }
      ],
    },
    { name: "Length_c135",
      desc: "Lenght of payload + header",
      swaccess: "rw",
      hwaccess: "none",
      fields: [
        { bits: "31:0" }
      ],
    },
    { name: "Message_Header_c135",
      desc: "Defines which commanad the message contains",
      swaccess: "rw",
      hwaccess: "none",
      fields: [
        { bits: "31:28" },
        { bits: "27:18",
          name: "Token",
          desc: "must be same for the msg responses associated to a msg whith the same header"
        },
        { bits: "17:10",
          name: "Protocol_Id",
          desc: "Identifies to which protocol the command belongs to"
        },
        { bits: "9:8",
          name: "Message_Type",
          desc: "can be 0,1,2,3 depending on the kind of msg to be sent"
        },
        { bits: "7:0",
          name: "Message_Id",
          desc: "unique identifier for each command availabe in the protocol pointed by protocol_id"
        }
      ],
    },
    { name: "Message_Payload_1_c135",
      desc: "memory region dedicated to the parameters of the commands and their returns",
      swaccess: "rw",
      hwaccess: "none",
      fields: [
        { bits: "31:0" }
      ],
    },
    { name: "Doorbell_c135",
      desc: "Rapresents the interrupt to be raised towards the platform",
      swaccess: "rw",
      hwaccess: "hro",
      fields: [
        { bits: "31:1",
          name: "Preserve_Mask",
          desc: "These bits must be constant to 0, not used with just one platform and one agent"
        },
        { bits: "0",
          name: "intr",
          desc: "Interrupt bit"
        }
      ],
    },
    { name:  "Completion_Interrupt_c135",
      desc: "Rapresent the interrupt the platform should raise when it finishes to execute the received command",
      swaccess: "rw",
      hwaccess: "hro",
      fields: [
        { bits: "31:1",
          name: "Preserve_Mask",
          desc: "These bits must be constant to 0, not used with just one platform and one agent"
        },
        { bits: "0",
          name: "intr",
          desc: "Interrupt bit"
        }
      ],
    },
    { name: "Reserved_1_c136",
      desc: "Reserved, must be 0",
      swaccess: "rw",
      hwaccess: "none",
      fields: [
        { bits: "31:0" }
      ],
    },
    { name: "Channel_Status_c136",
      desc: "Indicates which entity has access to the Shared Memory",
      swaccess: "rw",
      hwaccess: "none",
      fields: [
        { bits: "31:2" },
        { bits: "1",
          name: "channel_error",
          desc: "Must be 0 in absence of errors"
        },
        { bits: "0",
          name: "channel_free",
          desc: "If 1 the agent own the channel, if 0 the platform own the channel"
        }
      ],
    },
    { name: "Reserved_2_c136",
      desc: "Reserved, implementation defined (32 bits over 64)",
      swaccess: "rw",
      hwaccess: "none",
      fields: [
        { bits: "31:0" }
      ],
    },
    { name: "Reserved_3_c136",
      desc: "Reserved, implementation defined (32 bits over 64)",
      swaccess: "none",
      hwaccess: "none",
      fields: [
        { bits: "31:0" }
      ],
    },
    { name: "Channel_Flags_c136",
      desc: "Defines wheter interrupts or polling is used for communication",
      swaccess: "rw",
      hwaccess: "none",
      fields: [
        { bits: "31:1" },
        { bits: "0",
          name: "intr_enable",
          desc: "If 1 interruts are used, if 0 polling is used"
        }
      ],
    },
    { name: "Length_c136",
      desc: "Lenght of payload + header",
      swaccess: "rw",
      hwaccess: "none",
      fields: [
        { bits: "31:0" }
      ],
    },
    { name: "Message_Header_c136",
      desc: "Defines which commanad the message contains",
      swaccess: "rw",
      hwaccess: "none",
      fields: [
        { bits: "31:28" },
        { bits: "27:18",
          name: "Token",
          desc: "must be same for the msg responses associated to a msg whith the same header"
        },
        { bits: "17:10",
          name: "Protocol_Id",
          desc: "Identifies to which protocol the command belongs to"
        },
        { bits: "9:8",
          name: "Message_Type",
          desc: "can be 0,1,2,3 depending on the kind of msg to be sent"
        },
        { bits: "7:0",
          name: "Message_Id",
          desc: "unique identifier for each command availabe in the protocol pointed by protocol_id"
        }
      ],
    },
    { name: "Message_Payload_1_c136",
      desc: "memory region dedicated to the parameters of the commands and their returns",
      swaccess: "rw",
      hwaccess: "none",
      fields: [
        { bits: "31:0" }
      ],
    },
    { name: "Doorbell_c136",
      desc: "Rapresents the interrupt to be raised towards the platform",
      swaccess: "rw",
      hwaccess: "hro",
      fields: [
        { bits: "31:1",
          name: "Preserve_Mask",
          desc: "These bits must be constant to 0, not used with just one platform and one agent"
        },
        { bits: "0",
          name: "intr",
          desc: "Interrupt bit"
        }
      ],
    },
    { name:  "Completion_Interrupt_c136",
      desc: "Rapresent the interrupt the platform should raise when it finishes to execute the received command",
      swaccess: "rw",
      hwaccess: "hro",
      fields: [
        { bits: "31:1",
          name: "Preserve_Mask",
          desc: "These bits must be constant to 0, not used with just one platform and one agent"
        },
        { bits: "0",
          name: "intr",
          desc: "Interrupt bit"
        }
      ],
    },
    { name: "Reserved_1_c137",
      desc: "Reserved, must be 0",
      swaccess: "rw",
      hwaccess: "none",
      fields: [
        { bits: "31:0" }
      ],
    },
    { name: "Channel_Status_c137",
      desc: "Indicates which entity has access to the Shared Memory",
      swaccess: "rw",
      hwaccess: "none",
      fields: [
        { bits: "31:2" },
        { bits: "1",
          name: "channel_error",
          desc: "Must be 0 in absence of errors"
        },
        { bits: "0",
          name: "channel_free",
          desc: "If 1 the agent own the channel, if 0 the platform own the channel"
        }
      ],
    },
    { name: "Reserved_2_c137",
      desc: "Reserved, implementation defined (32 bits over 64)",
      swaccess: "rw",
      hwaccess: "none",
      fields: [
        { bits: "31:0" }
      ],
    },
    { name: "Reserved_3_c137",
      desc: "Reserved, implementation defined (32 bits over 64)",
      swaccess: "none",
      hwaccess: "none",
      fields: [
        { bits: "31:0" }
      ],
    },
    { name: "Channel_Flags_c137",
      desc: "Defines wheter interrupts or polling is used for communication",
      swaccess: "rw",
      hwaccess: "none",
      fields: [
        { bits: "31:1" },
        { bits: "0",
          name: "intr_enable",
          desc: "If 1 interruts are used, if 0 polling is used"
        }
      ],
    },
    { name: "Length_c137",
      desc: "Lenght of payload + header",
      swaccess: "rw",
      hwaccess: "none",
      fields: [
        { bits: "31:0" }
      ],
    },
    { name: "Message_Header_c137",
      desc: "Defines which commanad the message contains",
      swaccess: "rw",
      hwaccess: "none",
      fields: [
        { bits: "31:28" },
        { bits: "27:18",
          name: "Token",
          desc: "must be same for the msg responses associated to a msg whith the same header"
        },
        { bits: "17:10",
          name: "Protocol_Id",
          desc: "Identifies to which protocol the command belongs to"
        },
        { bits: "9:8",
          name: "Message_Type",
          desc: "can be 0,1,2,3 depending on the kind of msg to be sent"
        },
        { bits: "7:0",
          name: "Message_Id",
          desc: "unique identifier for each command availabe in the protocol pointed by protocol_id"
        }
      ],
    },
    { name: "Message_Payload_1_c137",
      desc: "memory region dedicated to the parameters of the commands and their returns",
      swaccess: "rw",
      hwaccess: "none",
      fields: [
        { bits: "31:0" }
      ],
    },
    { name: "Doorbell_c137",
      desc: "Rapresents the interrupt to be raised towards the platform",
      swaccess: "rw",
      hwaccess: "hro",
      fields: [
        { bits: "31:1",
          name: "Preserve_Mask",
          desc: "These bits must be constant to 0, not used with just one platform and one agent"
        },
        { bits: "0",
          name: "intr",
          desc: "Interrupt bit"
        }
      ],
    },
    { name:  "Completion_Interrupt_c137",
      desc: "Rapresent the interrupt the platform should raise when it finishes to execute the received command",
      swaccess: "rw",
      hwaccess: "hro",
      fields: [
        { bits: "31:1",
          name: "Preserve_Mask",
          desc: "These bits must be constant to 0, not used with just one platform and one agent"
        },
        { bits: "0",
          name: "intr",
          desc: "Interrupt bit"
        }
      ],
    },
    { name: "Reserved_1_c138",
      desc: "Reserved, must be 0",
      swaccess: "rw",
      hwaccess: "none",
      fields: [
        { bits: "31:0" }
      ],
    },
    { name: "Channel_Status_c138",
      desc: "Indicates which entity has access to the Shared Memory",
      swaccess: "rw",
      hwaccess: "none",
      fields: [
        { bits: "31:2" },
        { bits: "1",
          name: "channel_error",
          desc: "Must be 0 in absence of errors"
        },
        { bits: "0",
          name: "channel_free",
          desc: "If 1 the agent own the channel, if 0 the platform own the channel"
        }
      ],
    },
    { name: "Reserved_2_c138",
      desc: "Reserved, implementation defined (32 bits over 64)",
      swaccess: "rw",
      hwaccess: "none",
      fields: [
        { bits: "31:0" }
      ],
    },
    { name: "Reserved_3_c138",
      desc: "Reserved, implementation defined (32 bits over 64)",
      swaccess: "none",
      hwaccess: "none",
      fields: [
        { bits: "31:0" }
      ],
    },
    { name: "Channel_Flags_c138",
      desc: "Defines wheter interrupts or polling is used for communication",
      swaccess: "rw",
      hwaccess: "none",
      fields: [
        { bits: "31:1" },
        { bits: "0",
          name: "intr_enable",
          desc: "If 1 interruts are used, if 0 polling is used"
        }
      ],
    },
    { name: "Length_c138",
      desc: "Lenght of payload + header",
      swaccess: "rw",
      hwaccess: "none",
      fields: [
        { bits: "31:0" }
      ],
    },
    { name: "Message_Header_c138",
      desc: "Defines which commanad the message contains",
      swaccess: "rw",
      hwaccess: "none",
      fields: [
        { bits: "31:28" },
        { bits: "27:18",
          name: "Token",
          desc: "must be same for the msg responses associated to a msg whith the same header"
        },
        { bits: "17:10",
          name: "Protocol_Id",
          desc: "Identifies to which protocol the command belongs to"
        },
        { bits: "9:8",
          name: "Message_Type",
          desc: "can be 0,1,2,3 depending on the kind of msg to be sent"
        },
        { bits: "7:0",
          name: "Message_Id",
          desc: "unique identifier for each command availabe in the protocol pointed by protocol_id"
        }
      ],
    },
    { name: "Message_Payload_1_c138",
      desc: "memory region dedicated to the parameters of the commands and their returns",
      swaccess: "rw",
      hwaccess: "none",
      fields: [
        { bits: "31:0" }
      ],
    },
    { name: "Doorbell_c138",
      desc: "Rapresents the interrupt to be raised towards the platform",
      swaccess: "rw",
      hwaccess: "hro",
      fields: [
        { bits: "31:1",
          name: "Preserve_Mask",
          desc: "These bits must be constant to 0, not used with just one platform and one agent"
        },
        { bits: "0",
          name: "intr",
          desc: "Interrupt bit"
        }
      ],
    },
    { name:  "Completion_Interrupt_c138",
      desc: "Rapresent the interrupt the platform should raise when it finishes to execute the received command",
      swaccess: "rw",
      hwaccess: "hro",
      fields: [
        { bits: "31:1",
          name: "Preserve_Mask",
          desc: "These bits must be constant to 0, not used with just one platform and one agent"
        },
        { bits: "0",
          name: "intr",
          desc: "Interrupt bit"
        }
      ],
    },
    { name: "Reserved_1_c139",
      desc: "Reserved, must be 0",
      swaccess: "rw",
      hwaccess: "none",
      fields: [
        { bits: "31:0" }
      ],
    },
    { name: "Channel_Status_c139",
      desc: "Indicates which entity has access to the Shared Memory",
      swaccess: "rw",
      hwaccess: "none",
      fields: [
        { bits: "31:2" },
        { bits: "1",
          name: "channel_error",
          desc: "Must be 0 in absence of errors"
        },
        { bits: "0",
          name: "channel_free",
          desc: "If 1 the agent own the channel, if 0 the platform own the channel"
        }
      ],
    },
    { name: "Reserved_2_c139",
      desc: "Reserved, implementation defined (32 bits over 64)",
      swaccess: "rw",
      hwaccess: "none",
      fields: [
        { bits: "31:0" }
      ],
    },
    { name: "Reserved_3_c139",
      desc: "Reserved, implementation defined (32 bits over 64)",
      swaccess: "none",
      hwaccess: "none",
      fields: [
        { bits: "31:0" }
      ],
    },
    { name: "Channel_Flags_c139",
      desc: "Defines wheter interrupts or polling is used for communication",
      swaccess: "rw",
      hwaccess: "none",
      fields: [
        { bits: "31:1" },
        { bits: "0",
          name: "intr_enable",
          desc: "If 1 interruts are used, if 0 polling is used"
        }
      ],
    },
    { name: "Length_c139",
      desc: "Lenght of payload + header",
      swaccess: "rw",
      hwaccess: "none",
      fields: [
        { bits: "31:0" }
      ],
    },
    { name: "Message_Header_c139",
      desc: "Defines which commanad the message contains",
      swaccess: "rw",
      hwaccess: "none",
      fields: [
        { bits: "31:28" },
        { bits: "27:18",
          name: "Token",
          desc: "must be same for the msg responses associated to a msg whith the same header"
        },
        { bits: "17:10",
          name: "Protocol_Id",
          desc: "Identifies to which protocol the command belongs to"
        },
        { bits: "9:8",
          name: "Message_Type",
          desc: "can be 0,1,2,3 depending on the kind of msg to be sent"
        },
        { bits: "7:0",
          name: "Message_Id",
          desc: "unique identifier for each command availabe in the protocol pointed by protocol_id"
        }
      ],
    },
    { name: "Message_Payload_1_c139",
      desc: "memory region dedicated to the parameters of the commands and their returns",
      swaccess: "rw",
      hwaccess: "none",
      fields: [
        { bits: "31:0" }
      ],
    },
    { name: "Doorbell_c139",
      desc: "Rapresents the interrupt to be raised towards the platform",
      swaccess: "rw",
      hwaccess: "hro",
      fields: [
        { bits: "31:1",
          name: "Preserve_Mask",
          desc: "These bits must be constant to 0, not used with just one platform and one agent"
        },
        { bits: "0",
          name: "intr",
          desc: "Interrupt bit"
        }
      ],
    },
    { name:  "Completion_Interrupt_c139",
      desc: "Rapresent the interrupt the platform should raise when it finishes to execute the received command",
      swaccess: "rw",
      hwaccess: "hro",
      fields: [
        { bits: "31:1",
          name: "Preserve_Mask",
          desc: "These bits must be constant to 0, not used with just one platform and one agent"
        },
        { bits: "0",
          name: "intr",
          desc: "Interrupt bit"
        }
      ],
    },
    { name: "Reserved_1_c140",
      desc: "Reserved, must be 0",
      swaccess: "rw",
      hwaccess: "none",
      fields: [
        { bits: "31:0" }
      ],
    },
    { name: "Channel_Status_c140",
      desc: "Indicates which entity has access to the Shared Memory",
      swaccess: "rw",
      hwaccess: "none",
      fields: [
        { bits: "31:2" },
        { bits: "1",
          name: "channel_error",
          desc: "Must be 0 in absence of errors"
        },
        { bits: "0",
          name: "channel_free",
          desc: "If 1 the agent own the channel, if 0 the platform own the channel"
        }
      ],
    },
    { name: "Reserved_2_c140",
      desc: "Reserved, implementation defined (32 bits over 64)",
      swaccess: "rw",
      hwaccess: "none",
      fields: [
        { bits: "31:0" }
      ],
    },
    { name: "Reserved_3_c140",
      desc: "Reserved, implementation defined (32 bits over 64)",
      swaccess: "none",
      hwaccess: "none",
      fields: [
        { bits: "31:0" }
      ],
    },
    { name: "Channel_Flags_c140",
      desc: "Defines wheter interrupts or polling is used for communication",
      swaccess: "rw",
      hwaccess: "none",
      fields: [
        { bits: "31:1" },
        { bits: "0",
          name: "intr_enable",
          desc: "If 1 interruts are used, if 0 polling is used"
        }
      ],
    },
    { name: "Length_c140",
      desc: "Lenght of payload + header",
      swaccess: "rw",
      hwaccess: "none",
      fields: [
        { bits: "31:0" }
      ],
    },
    { name: "Message_Header_c140",
      desc: "Defines which commanad the message contains",
      swaccess: "rw",
      hwaccess: "none",
      fields: [
        { bits: "31:28" },
        { bits: "27:18",
          name: "Token",
          desc: "must be same for the msg responses associated to a msg whith the same header"
        },
        { bits: "17:10",
          name: "Protocol_Id",
          desc: "Identifies to which protocol the command belongs to"
        },
        { bits: "9:8",
          name: "Message_Type",
          desc: "can be 0,1,2,3 depending on the kind of msg to be sent"
        },
        { bits: "7:0",
          name: "Message_Id",
          desc: "unique identifier for each command availabe in the protocol pointed by protocol_id"
        }
      ],
    },
    { name: "Message_Payload_1_c140",
      desc: "memory region dedicated to the parameters of the commands and their returns",
      swaccess: "rw",
      hwaccess: "none",
      fields: [
        { bits: "31:0" }
      ],
    },
    { name: "Doorbell_c140",
      desc: "Rapresents the interrupt to be raised towards the platform",
      swaccess: "rw",
      hwaccess: "hro",
      fields: [
        { bits: "31:1",
          name: "Preserve_Mask",
          desc: "These bits must be constant to 0, not used with just one platform and one agent"
        },
        { bits: "0",
          name: "intr",
          desc: "Interrupt bit"
        }
      ],
    },
    { name:  "Completion_Interrupt_c140",
      desc: "Rapresent the interrupt the platform should raise when it finishes to execute the received command",
      swaccess: "rw",
      hwaccess: "hro",
      fields: [
        { bits: "31:1",
          name: "Preserve_Mask",
          desc: "These bits must be constant to 0, not used with just one platform and one agent"
        },
        { bits: "0",
          name: "intr",
          desc: "Interrupt bit"
        }
      ],
    },
    { name: "Reserved_1_c141",
      desc: "Reserved, must be 0",
      swaccess: "rw",
      hwaccess: "none",
      fields: [
        { bits: "31:0" }
      ],
    },
    { name: "Channel_Status_c141",
      desc: "Indicates which entity has access to the Shared Memory",
      swaccess: "rw",
      hwaccess: "none",
      fields: [
        { bits: "31:2" },
        { bits: "1",
          name: "channel_error",
          desc: "Must be 0 in absence of errors"
        },
        { bits: "0",
          name: "channel_free",
          desc: "If 1 the agent own the channel, if 0 the platform own the channel"
        }
      ],
    },
    { name: "Reserved_2_c141",
      desc: "Reserved, implementation defined (32 bits over 64)",
      swaccess: "rw",
      hwaccess: "none",
      fields: [
        { bits: "31:0" }
      ],
    },
    { name: "Reserved_3_c141",
      desc: "Reserved, implementation defined (32 bits over 64)",
      swaccess: "none",
      hwaccess: "none",
      fields: [
        { bits: "31:0" }
      ],
    },
    { name: "Channel_Flags_c141",
      desc: "Defines wheter interrupts or polling is used for communication",
      swaccess: "rw",
      hwaccess: "none",
      fields: [
        { bits: "31:1" },
        { bits: "0",
          name: "intr_enable",
          desc: "If 1 interruts are used, if 0 polling is used"
        }
      ],
    },
    { name: "Length_c141",
      desc: "Lenght of payload + header",
      swaccess: "rw",
      hwaccess: "none",
      fields: [
        { bits: "31:0" }
      ],
    },
    { name: "Message_Header_c141",
      desc: "Defines which commanad the message contains",
      swaccess: "rw",
      hwaccess: "none",
      fields: [
        { bits: "31:28" },
        { bits: "27:18",
          name: "Token",
          desc: "must be same for the msg responses associated to a msg whith the same header"
        },
        { bits: "17:10",
          name: "Protocol_Id",
          desc: "Identifies to which protocol the command belongs to"
        },
        { bits: "9:8",
          name: "Message_Type",
          desc: "can be 0,1,2,3 depending on the kind of msg to be sent"
        },
        { bits: "7:0",
          name: "Message_Id",
          desc: "unique identifier for each command availabe in the protocol pointed by protocol_id"
        }
      ],
    },
    { name: "Message_Payload_1_c141",
      desc: "memory region dedicated to the parameters of the commands and their returns",
      swaccess: "rw",
      hwaccess: "none",
      fields: [
        { bits: "31:0" }
      ],
    },
    { name: "Doorbell_c141",
      desc: "Rapresents the interrupt to be raised towards the platform",
      swaccess: "rw",
      hwaccess: "hro",
      fields: [
        { bits: "31:1",
          name: "Preserve_Mask",
          desc: "These bits must be constant to 0, not used with just one platform and one agent"
        },
        { bits: "0",
          name: "intr",
          desc: "Interrupt bit"
        }
      ],
    },
    { name:  "Completion_Interrupt_c141",
      desc: "Rapresent the interrupt the platform should raise when it finishes to execute the received command",
      swaccess: "rw",
      hwaccess: "hro",
      fields: [
        { bits: "31:1",
          name: "Preserve_Mask",
          desc: "These bits must be constant to 0, not used with just one platform and one agent"
        },
        { bits: "0",
          name: "intr",
          desc: "Interrupt bit"
        }
      ],
    },
    { name: "Reserved_1_c142",
      desc: "Reserved, must be 0",
      swaccess: "rw",
      hwaccess: "none",
      fields: [
        { bits: "31:0" }
      ],
    },
    { name: "Channel_Status_c142",
      desc: "Indicates which entity has access to the Shared Memory",
      swaccess: "rw",
      hwaccess: "none",
      fields: [
        { bits: "31:2" },
        { bits: "1",
          name: "channel_error",
          desc: "Must be 0 in absence of errors"
        },
        { bits: "0",
          name: "channel_free",
          desc: "If 1 the agent own the channel, if 0 the platform own the channel"
        }
      ],
    },
    { name: "Reserved_2_c142",
      desc: "Reserved, implementation defined (32 bits over 64)",
      swaccess: "rw",
      hwaccess: "none",
      fields: [
        { bits: "31:0" }
      ],
    },
    { name: "Reserved_3_c142",
      desc: "Reserved, implementation defined (32 bits over 64)",
      swaccess: "none",
      hwaccess: "none",
      fields: [
        { bits: "31:0" }
      ],
    },
    { name: "Channel_Flags_c142",
      desc: "Defines wheter interrupts or polling is used for communication",
      swaccess: "rw",
      hwaccess: "none",
      fields: [
        { bits: "31:1" },
        { bits: "0",
          name: "intr_enable",
          desc: "If 1 interruts are used, if 0 polling is used"
        }
      ],
    },
    { name: "Length_c142",
      desc: "Lenght of payload + header",
      swaccess: "rw",
      hwaccess: "none",
      fields: [
        { bits: "31:0" }
      ],
    },
    { name: "Message_Header_c142",
      desc: "Defines which commanad the message contains",
      swaccess: "rw",
      hwaccess: "none",
      fields: [
        { bits: "31:28" },
        { bits: "27:18",
          name: "Token",
          desc: "must be same for the msg responses associated to a msg whith the same header"
        },
        { bits: "17:10",
          name: "Protocol_Id",
          desc: "Identifies to which protocol the command belongs to"
        },
        { bits: "9:8",
          name: "Message_Type",
          desc: "can be 0,1,2,3 depending on the kind of msg to be sent"
        },
        { bits: "7:0",
          name: "Message_Id",
          desc: "unique identifier for each command availabe in the protocol pointed by protocol_id"
        }
      ],
    },
    { name: "Message_Payload_1_c142",
      desc: "memory region dedicated to the parameters of the commands and their returns",
      swaccess: "rw",
      hwaccess: "none",
      fields: [
        { bits: "31:0" }
      ],
    },
    { name: "Doorbell_c142",
      desc: "Rapresents the interrupt to be raised towards the platform",
      swaccess: "rw",
      hwaccess: "hro",
      fields: [
        { bits: "31:1",
          name: "Preserve_Mask",
          desc: "These bits must be constant to 0, not used with just one platform and one agent"
        },
        { bits: "0",
          name: "intr",
          desc: "Interrupt bit"
        }
      ],
    },
    { name:  "Completion_Interrupt_c142",
      desc: "Rapresent the interrupt the platform should raise when it finishes to execute the received command",
      swaccess: "rw",
      hwaccess: "hro",
      fields: [
        { bits: "31:1",
          name: "Preserve_Mask",
          desc: "These bits must be constant to 0, not used with just one platform and one agent"
        },
        { bits: "0",
          name: "intr",
          desc: "Interrupt bit"
        }
      ],
    },
    { name: "Reserved_1_c143",
      desc: "Reserved, must be 0",
      swaccess: "rw",
      hwaccess: "none",
      fields: [
        { bits: "31:0" }
      ],
    },
    { name: "Channel_Status_c143",
      desc: "Indicates which entity has access to the Shared Memory",
      swaccess: "rw",
      hwaccess: "none",
      fields: [
        { bits: "31:2" },
        { bits: "1",
          name: "channel_error",
          desc: "Must be 0 in absence of errors"
        },
        { bits: "0",
          name: "channel_free",
          desc: "If 1 the agent own the channel, if 0 the platform own the channel"
        }
      ],
    },
    { name: "Reserved_2_c143",
      desc: "Reserved, implementation defined (32 bits over 64)",
      swaccess: "rw",
      hwaccess: "none",
      fields: [
        { bits: "31:0" }
      ],
    },
    { name: "Reserved_3_c143",
      desc: "Reserved, implementation defined (32 bits over 64)",
      swaccess: "none",
      hwaccess: "none",
      fields: [
        { bits: "31:0" }
      ],
    },
    { name: "Channel_Flags_c143",
      desc: "Defines wheter interrupts or polling is used for communication",
      swaccess: "rw",
      hwaccess: "none",
      fields: [
        { bits: "31:1" },
        { bits: "0",
          name: "intr_enable",
          desc: "If 1 interruts are used, if 0 polling is used"
        }
      ],
    },
    { name: "Length_c143",
      desc: "Lenght of payload + header",
      swaccess: "rw",
      hwaccess: "none",
      fields: [
        { bits: "31:0" }
      ],
    },
    { name: "Message_Header_c143",
      desc: "Defines which commanad the message contains",
      swaccess: "rw",
      hwaccess: "none",
      fields: [
        { bits: "31:28" },
        { bits: "27:18",
          name: "Token",
          desc: "must be same for the msg responses associated to a msg whith the same header"
        },
        { bits: "17:10",
          name: "Protocol_Id",
          desc: "Identifies to which protocol the command belongs to"
        },
        { bits: "9:8",
          name: "Message_Type",
          desc: "can be 0,1,2,3 depending on the kind of msg to be sent"
        },
        { bits: "7:0",
          name: "Message_Id",
          desc: "unique identifier for each command availabe in the protocol pointed by protocol_id"
        }
      ],
    },
    { name: "Message_Payload_1_c143",
      desc: "memory region dedicated to the parameters of the commands and their returns",
      swaccess: "rw",
      hwaccess: "none",
      fields: [
        { bits: "31:0" }
      ],
    },
    { name: "Doorbell_c143",
      desc: "Rapresents the interrupt to be raised towards the platform",
      swaccess: "rw",
      hwaccess: "hro",
      fields: [
        { bits: "31:1",
          name: "Preserve_Mask",
          desc: "These bits must be constant to 0, not used with just one platform and one agent"
        },
        { bits: "0",
          name: "intr",
          desc: "Interrupt bit"
        }
      ],
    },
    { name:  "Completion_Interrupt_c143",
      desc: "Rapresent the interrupt the platform should raise when it finishes to execute the received command",
      swaccess: "rw",
      hwaccess: "hro",
      fields: [
        { bits: "31:1",
          name: "Preserve_Mask",
          desc: "These bits must be constant to 0, not used with just one platform and one agent"
        },
        { bits: "0",
          name: "intr",
          desc: "Interrupt bit"
        }
      ],
    },
    { name: "Reserved_1_c144",
      desc: "Reserved, must be 0",
      swaccess: "rw",
      hwaccess: "none",
      fields: [
        { bits: "31:0" }
      ],
    },
    { name: "Channel_Status_c144",
      desc: "Indicates which entity has access to the Shared Memory",
      swaccess: "rw",
      hwaccess: "none",
      fields: [
        { bits: "31:2" },
        { bits: "1",
          name: "channel_error",
          desc: "Must be 0 in absence of errors"
        },
        { bits: "0",
          name: "channel_free",
          desc: "If 1 the agent own the channel, if 0 the platform own the channel"
        }
      ],
    },
    { name: "Reserved_2_c144",
      desc: "Reserved, implementation defined (32 bits over 64)",
      swaccess: "rw",
      hwaccess: "none",
      fields: [
        { bits: "31:0" }
      ],
    },
    { name: "Reserved_3_c144",
      desc: "Reserved, implementation defined (32 bits over 64)",
      swaccess: "none",
      hwaccess: "none",
      fields: [
        { bits: "31:0" }
      ],
    },
    { name: "Channel_Flags_c144",
      desc: "Defines wheter interrupts or polling is used for communication",
      swaccess: "rw",
      hwaccess: "none",
      fields: [
        { bits: "31:1" },
        { bits: "0",
          name: "intr_enable",
          desc: "If 1 interruts are used, if 0 polling is used"
        }
      ],
    },
    { name: "Length_c144",
      desc: "Lenght of payload + header",
      swaccess: "rw",
      hwaccess: "none",
      fields: [
        { bits: "31:0" }
      ],
    },
    { name: "Message_Header_c144",
      desc: "Defines which commanad the message contains",
      swaccess: "rw",
      hwaccess: "none",
      fields: [
        { bits: "31:28" },
        { bits: "27:18",
          name: "Token",
          desc: "must be same for the msg responses associated to a msg whith the same header"
        },
        { bits: "17:10",
          name: "Protocol_Id",
          desc: "Identifies to which protocol the command belongs to"
        },
        { bits: "9:8",
          name: "Message_Type",
          desc: "can be 0,1,2,3 depending on the kind of msg to be sent"
        },
        { bits: "7:0",
          name: "Message_Id",
          desc: "unique identifier for each command availabe in the protocol pointed by protocol_id"
        }
      ],
    },
    { name: "Message_Payload_1_c144",
      desc: "memory region dedicated to the parameters of the commands and their returns",
      swaccess: "rw",
      hwaccess: "none",
      fields: [
        { bits: "31:0" }
      ],
    },
    { name: "Doorbell_c144",
      desc: "Rapresents the interrupt to be raised towards the platform",
      swaccess: "rw",
      hwaccess: "hro",
      fields: [
        { bits: "31:1",
          name: "Preserve_Mask",
          desc: "These bits must be constant to 0, not used with just one platform and one agent"
        },
        { bits: "0",
          name: "intr",
          desc: "Interrupt bit"
        }
      ],
    },
    { name:  "Completion_Interrupt_c144",
      desc: "Rapresent the interrupt the platform should raise when it finishes to execute the received command",
      swaccess: "rw",
      hwaccess: "hro",
      fields: [
        { bits: "31:1",
          name: "Preserve_Mask",
          desc: "These bits must be constant to 0, not used with just one platform and one agent"
        },
        { bits: "0",
          name: "intr",
          desc: "Interrupt bit"
        }
      ],
    },
    { name: "Reserved_1_c145",
      desc: "Reserved, must be 0",
      swaccess: "rw",
      hwaccess: "none",
      fields: [
        { bits: "31:0" }
      ],
    },
    { name: "Channel_Status_c145",
      desc: "Indicates which entity has access to the Shared Memory",
      swaccess: "rw",
      hwaccess: "none",
      fields: [
        { bits: "31:2" },
        { bits: "1",
          name: "channel_error",
          desc: "Must be 0 in absence of errors"
        },
        { bits: "0",
          name: "channel_free",
          desc: "If 1 the agent own the channel, if 0 the platform own the channel"
        }
      ],
    },
    { name: "Reserved_2_c145",
      desc: "Reserved, implementation defined (32 bits over 64)",
      swaccess: "rw",
      hwaccess: "none",
      fields: [
        { bits: "31:0" }
      ],
    },
    { name: "Reserved_3_c145",
      desc: "Reserved, implementation defined (32 bits over 64)",
      swaccess: "none",
      hwaccess: "none",
      fields: [
        { bits: "31:0" }
      ],
    },
    { name: "Channel_Flags_c145",
      desc: "Defines wheter interrupts or polling is used for communication",
      swaccess: "rw",
      hwaccess: "none",
      fields: [
        { bits: "31:1" },
        { bits: "0",
          name: "intr_enable",
          desc: "If 1 interruts are used, if 0 polling is used"
        }
      ],
    },
    { name: "Length_c145",
      desc: "Lenght of payload + header",
      swaccess: "rw",
      hwaccess: "none",
      fields: [
        { bits: "31:0" }
      ],
    },
    { name: "Message_Header_c145",
      desc: "Defines which commanad the message contains",
      swaccess: "rw",
      hwaccess: "none",
      fields: [
        { bits: "31:28" },
        { bits: "27:18",
          name: "Token",
          desc: "must be same for the msg responses associated to a msg whith the same header"
        },
        { bits: "17:10",
          name: "Protocol_Id",
          desc: "Identifies to which protocol the command belongs to"
        },
        { bits: "9:8",
          name: "Message_Type",
          desc: "can be 0,1,2,3 depending on the kind of msg to be sent"
        },
        { bits: "7:0",
          name: "Message_Id",
          desc: "unique identifier for each command availabe in the protocol pointed by protocol_id"
        }
      ],
    },
    { name: "Message_Payload_1_c145",
      desc: "memory region dedicated to the parameters of the commands and their returns",
      swaccess: "rw",
      hwaccess: "none",
      fields: [
        { bits: "31:0" }
      ],
    },
    { name: "Doorbell_c145",
      desc: "Rapresents the interrupt to be raised towards the platform",
      swaccess: "rw",
      hwaccess: "hro",
      fields: [
        { bits: "31:1",
          name: "Preserve_Mask",
          desc: "These bits must be constant to 0, not used with just one platform and one agent"
        },
        { bits: "0",
          name: "intr",
          desc: "Interrupt bit"
        }
      ],
    },
    { name:  "Completion_Interrupt_c145",
      desc: "Rapresent the interrupt the platform should raise when it finishes to execute the received command",
      swaccess: "rw",
      hwaccess: "hro",
      fields: [
        { bits: "31:1",
          name: "Preserve_Mask",
          desc: "These bits must be constant to 0, not used with just one platform and one agent"
        },
        { bits: "0",
          name: "intr",
          desc: "Interrupt bit"
        }
      ],
    },
    { name: "Reserved_1_c146",
      desc: "Reserved, must be 0",
      swaccess: "rw",
      hwaccess: "none",
      fields: [
        { bits: "31:0" }
      ],
    },
    { name: "Channel_Status_c146",
      desc: "Indicates which entity has access to the Shared Memory",
      swaccess: "rw",
      hwaccess: "none",
      fields: [
        { bits: "31:2" },
        { bits: "1",
          name: "channel_error",
          desc: "Must be 0 in absence of errors"
        },
        { bits: "0",
          name: "channel_free",
          desc: "If 1 the agent own the channel, if 0 the platform own the channel"
        }
      ],
    },
    { name: "Reserved_2_c146",
      desc: "Reserved, implementation defined (32 bits over 64)",
      swaccess: "rw",
      hwaccess: "none",
      fields: [
        { bits: "31:0" }
      ],
    },
    { name: "Reserved_3_c146",
      desc: "Reserved, implementation defined (32 bits over 64)",
      swaccess: "none",
      hwaccess: "none",
      fields: [
        { bits: "31:0" }
      ],
    },
    { name: "Channel_Flags_c146",
      desc: "Defines wheter interrupts or polling is used for communication",
      swaccess: "rw",
      hwaccess: "none",
      fields: [
        { bits: "31:1" },
        { bits: "0",
          name: "intr_enable",
          desc: "If 1 interruts are used, if 0 polling is used"
        }
      ],
    },
    { name: "Length_c146",
      desc: "Lenght of payload + header",
      swaccess: "rw",
      hwaccess: "none",
      fields: [
        { bits: "31:0" }
      ],
    },
    { name: "Message_Header_c146",
      desc: "Defines which commanad the message contains",
      swaccess: "rw",
      hwaccess: "none",
      fields: [
        { bits: "31:28" },
        { bits: "27:18",
          name: "Token",
          desc: "must be same for the msg responses associated to a msg whith the same header"
        },
        { bits: "17:10",
          name: "Protocol_Id",
          desc: "Identifies to which protocol the command belongs to"
        },
        { bits: "9:8",
          name: "Message_Type",
          desc: "can be 0,1,2,3 depending on the kind of msg to be sent"
        },
        { bits: "7:0",
          name: "Message_Id",
          desc: "unique identifier for each command availabe in the protocol pointed by protocol_id"
        }
      ],
    },
    { name: "Message_Payload_1_c146",
      desc: "memory region dedicated to the parameters of the commands and their returns",
      swaccess: "rw",
      hwaccess: "none",
      fields: [
        { bits: "31:0" }
      ],
    },
    { name: "Doorbell_c146",
      desc: "Rapresents the interrupt to be raised towards the platform",
      swaccess: "rw",
      hwaccess: "hro",
      fields: [
        { bits: "31:1",
          name: "Preserve_Mask",
          desc: "These bits must be constant to 0, not used with just one platform and one agent"
        },
        { bits: "0",
          name: "intr",
          desc: "Interrupt bit"
        }
      ],
    },
    { name:  "Completion_Interrupt_c146",
      desc: "Rapresent the interrupt the platform should raise when it finishes to execute the received command",
      swaccess: "rw",
      hwaccess: "hro",
      fields: [
        { bits: "31:1",
          name: "Preserve_Mask",
          desc: "These bits must be constant to 0, not used with just one platform and one agent"
        },
        { bits: "0",
          name: "intr",
          desc: "Interrupt bit"
        }
      ],
    },
  ],
}

